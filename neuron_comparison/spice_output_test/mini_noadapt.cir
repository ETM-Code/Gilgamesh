* ================================================================
* gilgamesh SPICE Mini - Single Neuron
* ================================================================
* Simulation time: 5.00ms
* Membrane: C=1.000e-8F, R=1.200e5Ω, tau=1.20ms
* Input current: 10.000uA

* ========== LIF Neuron Detailed Subcircuit (Pulse Stretching) ==========
* Passive membrane with comparator, reset, and pulse stretching
* Nodes: mem vref vdd comp_pulse sum
.subckt lif_neuron mem vref vdd comp_pulse sum

* ---------- Passive membrane ----------
Rsum mem sum 1m
Cmem mem vref 1.000e-8 IC=0.000000
Rleak mem vref 1.200e5

* ---------- Threshold divider (GND referenced) ----------
Rtop vdd vth_node 8.300e6
Rbottom vth_node vref 1.580e6
Cadapt vth_node vref 4.700e-9 IC=0.799595
* Inject current into vth_node when comp_out is high (avoids loading divider)

* ---------- Comparator model (finite delay, rail output) ----------
.param VLO=0
.param VHI=5
.param VSW=1.000000e-5
Bdef vdef 0 V = V(mem) - V(vref)
Btheta_rel vtheta_rel 0 V = V(vth_node) - V(vref)
Bcomp comp_raw 0 V = VLO + (VHI - VLO)*(0.5*(1 + tanh( ( V(vdef) - ( V(vtheta_rel) + 0 ) ) / VSW )))
Rcout comp_raw comp_ctrl 1.000e1
Ccout comp_ctrl 0 4.000e-9 IC=0
Bcomp_inv comp_inv 0 V = V(vdd) - V(comp_ctrl)
Scomp_hi comp_out vdd comp_ctrl 0 SWCOMP_HI
Scomp_lo comp_out vref comp_inv 0 SWCOMP_LO
.model SWCOMP_HI SW(Ron=50 Roff=1.000e9 Vt=2.500 Vh=0.050)
.model SWCOMP_LO SW(Ron=50 Roff=1.000e9 Vt=2.500 Vh=0.050)
Icomp_bias vdd 0 2.000e-6

* ---------- Pulse stretching circuit ----------
* tau_pulse = 1.000e5Ω × 5.000e-9F = 0.50ms
* Linear RC pulse stretcher (stable for ngspice)
Rpw_charge comp_out comp_pulse 10
Rpw comp_pulse 0 1.000e5
Cpw comp_pulse 0 5.000e-9 IC=0

* ---------- Reset path ----------
Creset mem vref 7.000e-12 IC=0
Sreset mem vref comp_out 0 SWMUX
.model SWMUX SW(Ron=10 Roff=1.000e9 Vt=2.5 Vh=0.1)

.ends lif_neuron

* ========== Power Supplies ==========
Vdd vdd 0 DC 5
Vref vref 0 DC 0

* ========== Single Neuron ==========
Xn mem vref vdd pulse sum lif_neuron
Iin 0 sum DC 1.000000e-5

* ========== Simulation ==========
.options reltol=1e-2 abstol=1e-9 vntol=1e-4
.tran 1.000000e-6 5.000000e-3

.control
run
set filetype=ascii
wrdata mini_output.txt v(mem) v(pulse) v(xn.comp_out) v(xn.vth_node) v(xn.comp_raw) v(xn.comp_ctrl)
quit
.endc

.end
