* Passive LIF Neuron Test - Gilgamesh Comparison
* Generated by neuron_compare.py

.include /Users/eoghancollins/Tarskii/gilgamesh/neuron_comparison/neuron_passive.subckt

* Power supplies
Vdd vdd 0 DC 5.0
Vref vref 0 DC 2.5

* Neuron instance (pins: mem vref vdd comp_pulse sum)
Xneuron mem vref vdd comp_pulse sum lif_passive_passive

* Constant current input
Iin 0 sum DC 1e-05

* Initial conditions
.ic V(mem)=2.5

* Transient analysis
.tran 1e-06 0.05 0 1e-06

* Save membrane, pulse output, and comparator output
.control
run
wrdata /Users/eoghancollins/Tarskii/gilgamesh/neuron_comparison/spice_output.csv v(mem) v(comp_pulse) v(xneuron.comp_out)
.endc

.end
