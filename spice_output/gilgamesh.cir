* ================================================================
* gilgamesh SNN - SPICE Simulation (Detailed Pulse-Stretch Model)
* ================================================================
* Architecture: 49 -> 9 -> 10
* Simulation time: 25.00ms
* Model dt: 1.000ms, SPICE step: 1.000us
* Membrane: C=1.000e-8F, R=1.200e5Ω, tau=1.20ms
* Pulse stretch: tau=0.50ms (enabled=true)
* Threshold: Vref+0.80V, hysteresis=0.050V
* Analog output: enabled=false

* ========== LIF Neuron Detailed Subcircuit (Pulse Stretching) ==========
* Passive membrane with comparator, reset, and pulse stretching
* Nodes: mem vref vdd comp_pulse sum
.subckt lif_neuron mem vref vdd comp_pulse sum

* ---------- Passive membrane ----------
Rsum mem sum 1m
Cmem mem vref 1.000e-8 IC=0.000000
Rleak mem vref 1.200e5

* ---------- Threshold divider (GND referenced) ----------
Rtop vdd vth_node 8.300e6
Rbottom vth_node vref 1.580e6
Cadapt vth_node vref 4.700e-9 IC=0.799595
.model DADAPT D(Is=1e-12 N=1.05 Rs=2 Cjo=1p Eg=0.69)
Rinj comp_out ninj 2.200e6
Dinj ninj vth_node DADAPT
R3 comp_out vref 2.150e7

* ---------- Comparator model (finite delay, rail output) ----------
.param VLO=0
.param VHI=5
.param VSW=0.0000
Bdef vdef 0 V = V(mem) - V(vref)
Btheta_rel vtheta_rel 0 V = V(vth_node) - V(vref)
Bcomp comp_raw 0 V = VLO + (VHI - VLO)*(0.5*(1 + tanh( ( V(vdef) - ( V(vtheta_rel) + 0 ) ) / VSW )))
Rcout comp_raw comp_ctrl 1.000e1
Ccout comp_ctrl 0 4.000e-9 IC=0
Bcomp_inv comp_inv 0 V = V(vdd) - V(comp_ctrl)
Scomp_hi comp_out vdd comp_ctrl 0 SWCOMP_HI
Scomp_lo comp_out vref comp_inv 0 SWCOMP_LO
.model SWCOMP_HI SW(Ron=50 Roff=1.000e9 Vt=2.500 Vh=0.050)
.model SWCOMP_LO SW(Ron=50 Roff=1.000e9 Vt=2.500 Vh=0.050)
Icomp_bias vdd 0 2.000e-6

* ---------- Pulse stretching circuit ----------
* tau_pulse = 1.000e5Ω × 5.000e-9F = 0.50ms
* Diode allows fast charging, slow discharge through Rpw
.model DPW D(Is=1e-12 N=1.05 Rs=10 Cjo=1p)
Dpw comp_out comp_pulse DPW
Rpw comp_pulse 0 1.000e5
Cpw comp_pulse 0 5.000e-9 IC=0

* ---------- Reset path ----------
Creset mem vref 7.000e-12 IC=0
Sreset mem vref comp_out 0 SWMUX
.model SWMUX SW(Ron=10 Roff=1.000e9 Vt=2.5 Vh=0.1)

.ends lif_neuron

* ========== Power Supplies ==========
Vdd vdd 0 DC 5
Vref vref 0 DC 0

* ========== Input Voltage Sources ==========
* Inputs scaled to voltage around Vref
Vin_0 in_0 0 DC -0.424213
Vin_1 in_1 0 DC -0.424213
Vin_2 in_2 0 DC -0.424213
Vin_3 in_3 0 DC -0.424213
Vin_4 in_4 0 DC -0.424213
Vin_5 in_5 0 DC -0.424213
Vin_6 in_6 0 DC -0.424213
Vin_7 in_7 0 DC -0.424213
Vin_8 in_8 0 DC -0.424213
Vin_9 in_9 0 DC -0.424213
Vin_10 in_10 0 DC -0.374096
Vin_11 in_11 0 DC 1.138178
Vin_12 in_12 0 DC 1.362513
Vin_13 in_13 0 DC -0.040775
Vin_14 in_14 0 DC -0.424213
Vin_15 in_15 0 DC -0.424213
Vin_16 in_16 0 DC -0.005772
Vin_17 in_17 0 DC 1.987787
Vin_18 in_18 0 DC 0.639390
Vin_19 in_19 0 DC -0.424213
Vin_20 in_20 0 DC -0.424213
Vin_21 in_21 0 DC -0.424213
Vin_22 in_22 0 DC 0.431761
Vin_23 in_23 0 DC 1.940056
Vin_24 in_24 0 DC 0.285386
Vin_25 in_25 0 DC 0.140602
Vin_26 in_26 0 DC -0.374096
Vin_27 in_27 0 DC -0.424213
Vin_28 in_28 0 DC -0.424213
Vin_29 in_29 0 DC 1.590826
Vin_30 in_30 0 DC 1.143746
Vin_31 in_31 0 DC 2.006084
Vin_32 in_32 0 DC 1.388765
Vin_33 in_33 0 DC 1.473089
Vin_34 in_34 0 DC -0.424213
Vin_35 in_35 0 DC -0.424213
Vin_36 in_36 0 DC -0.339888
Vin_37 in_37 0 DC 0.831109
Vin_38 in_38 0 DC 1.089651
Vin_39 in_39 0 DC 0.778605
Vin_40 in_40 0 DC -0.141010
Vin_41 in_41 0 DC -0.424213
Vin_42 in_42 0 DC -0.424213
Vin_43 in_43 0 DC -0.424213
Vin_44 in_44 0 DC -0.424213
Vin_45 in_45 0 DC -0.424213
Vin_46 in_46 0 DC -0.424213
Vin_47 in_47 0 DC -0.424213
Vin_48 in_48 0 DC -0.424213

* ========== Hidden Layer Neurons ==========
Xh_0 mem_h_0 vref vdd pulse_h_0 sum_h_0 lif_neuron
Xh_1 mem_h_1 vref vdd pulse_h_1 sum_h_1 lif_neuron
Xh_2 mem_h_2 vref vdd pulse_h_2 sum_h_2 lif_neuron
Xh_3 mem_h_3 vref vdd pulse_h_3 sum_h_3 lif_neuron
Xh_4 mem_h_4 vref vdd pulse_h_4 sum_h_4 lif_neuron
Xh_5 mem_h_5 vref vdd pulse_h_5 sum_h_5 lif_neuron
Xh_6 mem_h_6 vref vdd pulse_h_6 sum_h_6 lif_neuron
Xh_7 mem_h_7 vref vdd pulse_h_7 sum_h_7 lif_neuron
Xh_8 mem_h_8 vref vdd pulse_h_8 sum_h_8 lif_neuron

* ========== Input -> Hidden Synapses (VCCS) ==========
* G<name> n+ n- nc+ nc- transconductance
* Current from n+ to n- = transconductance * (V(nc+) - V(nc-))
Gw1_0_0 0 sum_h_0 in_0 vref 7.444613e-7
Gw1_1_0 0 sum_h_0 in_1 vref 1.693003e-6
Gw1_2_0 0 sum_h_0 in_2 vref 2.226747e-6
Gw1_3_0 0 sum_h_0 in_3 vref 4.502064e-6
Gw1_4_0 0 sum_h_0 in_4 vref 1.647362e-6
Gw1_5_0 0 sum_h_0 in_5 vref -1.535365e-6
Gw1_6_0 0 sum_h_0 in_6 vref -5.556400e-7
Gw1_7_0 0 sum_h_0 in_7 vref 1.905119e-6
Gw1_8_0 0 sum_h_0 in_8 vref -7.720045e-7
Gw1_9_0 0 sum_h_0 in_9 vref 9.433809e-7
Gw1_10_0 0 sum_h_0 in_10 vref 2.078245e-6
Gw1_11_0 0 sum_h_0 in_11 vref 5.884187e-7
Gw1_12_0 0 sum_h_0 in_12 vref -1.546171e-6
Gw1_13_0 0 sum_h_0 in_13 vref -5.028928e-7
Gw1_14_0 0 sum_h_0 in_14 vref 1.036650e-6
Gw1_15_0 0 sum_h_0 in_15 vref 1.440911e-6
Gw1_16_0 0 sum_h_0 in_16 vref -1.744171e-6
Gw1_17_0 0 sum_h_0 in_17 vref -1.523502e-6
Gw1_18_0 0 sum_h_0 in_18 vref -3.207723e-6
Gw1_19_0 0 sum_h_0 in_19 vref -6.368631e-7
Gw1_20_0 0 sum_h_0 in_20 vref -2.040518e-6
Gw1_21_0 0 sum_h_0 in_21 vref -2.302592e-6
Gw1_22_0 0 sum_h_0 in_22 vref -6.140647e-6
Gw1_23_0 0 sum_h_0 in_23 vref -2.859808e-6
Gw1_24_0 0 sum_h_0 in_24 vref 4.552577e-6
Gw1_25_0 0 sum_h_0 in_25 vref -1.200673e-7
Gw1_26_0 0 sum_h_0 in_26 vref -6.159946e-7
Gw1_27_0 0 sum_h_0 in_27 vref -3.894799e-7
Gw1_28_0 0 sum_h_0 in_28 vref 4.527112e-9
Gw1_29_0 0 sum_h_0 in_29 vref 1.448729e-6
Gw1_30_0 0 sum_h_0 in_30 vref 2.265659e-6
Gw1_31_0 0 sum_h_0 in_31 vref 1.712629e-6
Gw1_32_0 0 sum_h_0 in_32 vref 3.205976e-7
Gw1_33_0 0 sum_h_0 in_33 vref 2.048140e-6
Gw1_34_0 0 sum_h_0 in_34 vref 3.109700e-6
Gw1_35_0 0 sum_h_0 in_35 vref -1.163834e-6
Gw1_36_0 0 sum_h_0 in_36 vref 3.947712e-6
Gw1_37_0 0 sum_h_0 in_37 vref 1.778576e-6
Gw1_38_0 0 sum_h_0 in_38 vref 1.448853e-6
Gw1_39_0 0 sum_h_0 in_39 vref 2.964312e-6
Gw1_40_0 0 sum_h_0 in_40 vref 2.145008e-6
Gw1_41_0 0 sum_h_0 in_41 vref 7.042543e-7
Gw1_42_0 0 sum_h_0 in_42 vref -6.849309e-7
Gw1_43_0 0 sum_h_0 in_43 vref -4.440520e-6
Gw1_44_0 0 sum_h_0 in_44 vref -2.708332e-6
Gw1_45_0 0 sum_h_0 in_45 vref -2.423945e-7
Gw1_46_0 0 sum_h_0 in_46 vref -2.392611e-6
Gw1_47_0 0 sum_h_0 in_47 vref -2.493318e-6
Gw1_48_0 0 sum_h_0 in_48 vref -4.753536e-6
Gw1_0_1 0 sum_h_1 in_0 vref -8.028310e-7
Gw1_1_1 0 sum_h_1 in_1 vref 9.205908e-7
Gw1_2_1 0 sum_h_1 in_2 vref -2.572519e-6
Gw1_3_1 0 sum_h_1 in_3 vref -4.080457e-6
Gw1_4_1 0 sum_h_1 in_4 vref -2.415087e-6
Gw1_5_1 0 sum_h_1 in_5 vref 9.330640e-7
Gw1_6_1 0 sum_h_1 in_6 vref -1.893350e-6
Gw1_7_1 0 sum_h_1 in_7 vref 3.791925e-6
Gw1_8_1 0 sum_h_1 in_8 vref -1.311392e-6
Gw1_9_1 0 sum_h_1 in_9 vref -1.212699e-6
Gw1_10_1 0 sum_h_1 in_10 vref 2.218620e-6
Gw1_11_1 0 sum_h_1 in_11 vref 7.449615e-7
Gw1_12_1 0 sum_h_1 in_12 vref 7.461666e-7
Gw1_13_1 0 sum_h_1 in_13 vref 2.307190e-6
Gw1_14_1 0 sum_h_1 in_14 vref -3.257554e-6
Gw1_15_1 0 sum_h_1 in_15 vref -8.283426e-8
Gw1_16_1 0 sum_h_1 in_16 vref 2.214672e-6
Gw1_17_1 0 sum_h_1 in_17 vref -4.342386e-7
Gw1_18_1 0 sum_h_1 in_18 vref -2.598517e-6
Gw1_19_1 0 sum_h_1 in_19 vref 1.881123e-6
Gw1_20_1 0 sum_h_1 in_20 vref 1.101981e-6
Gw1_21_1 0 sum_h_1 in_21 vref -7.026814e-7
Gw1_22_1 0 sum_h_1 in_22 vref 6.381285e-7
Gw1_23_1 0 sum_h_1 in_23 vref 2.830418e-6
Gw1_24_1 0 sum_h_1 in_24 vref 4.694852e-6
Gw1_25_1 0 sum_h_1 in_25 vref 3.903065e-6
Gw1_26_1 0 sum_h_1 in_26 vref 9.345693e-8
Gw1_27_1 0 sum_h_1 in_27 vref -1.002278e-6
Gw1_28_1 0 sum_h_1 in_28 vref -1.566348e-6
Gw1_29_1 0 sum_h_1 in_29 vref -4.087939e-6
Gw1_30_1 0 sum_h_1 in_30 vref 7.520348e-7
Gw1_31_1 0 sum_h_1 in_31 vref -7.837046e-7
Gw1_32_1 0 sum_h_1 in_32 vref -9.825525e-7
Gw1_33_1 0 sum_h_1 in_33 vref -2.849491e-6
Gw1_34_1 0 sum_h_1 in_34 vref -1.788014e-6
Gw1_35_1 0 sum_h_1 in_35 vref -1.884905e-6
Gw1_36_1 0 sum_h_1 in_36 vref -2.117176e-6
Gw1_37_1 0 sum_h_1 in_37 vref -2.708742e-6
Gw1_38_1 0 sum_h_1 in_38 vref 3.895185e-7
Gw1_39_1 0 sum_h_1 in_39 vref -5.089416e-7
Gw1_40_1 0 sum_h_1 in_40 vref -2.277847e-6
Gw1_41_1 0 sum_h_1 in_41 vref -3.199936e-6
Gw1_42_1 0 sum_h_1 in_42 vref -2.447707e-6
Gw1_43_1 0 sum_h_1 in_43 vref -2.419631e-6
Gw1_44_1 0 sum_h_1 in_44 vref 1.680304e-6
Gw1_45_1 0 sum_h_1 in_45 vref 3.755420e-6
Gw1_46_1 0 sum_h_1 in_46 vref 3.706948e-6
Gw1_47_1 0 sum_h_1 in_47 vref 4.786361e-6
Gw1_48_1 0 sum_h_1 in_48 vref 2.571086e-6
Gw1_0_2 0 sum_h_2 in_0 vref 2.927418e-6
Gw1_1_2 0 sum_h_2 in_1 vref 2.260689e-6
Gw1_2_2 0 sum_h_2 in_2 vref -8.494644e-7
Gw1_3_2 0 sum_h_2 in_3 vref 4.946293e-6
Gw1_4_2 0 sum_h_2 in_4 vref 3.253606e-7
Gw1_5_2 0 sum_h_2 in_5 vref 2.077657e-7
Gw1_6_2 0 sum_h_2 in_6 vref 1.145234e-6
Gw1_7_2 0 sum_h_2 in_7 vref 4.621934e-7
Gw1_8_2 0 sum_h_2 in_8 vref -6.470020e-7
Gw1_9_2 0 sum_h_2 in_9 vref 4.369429e-6
Gw1_10_2 0 sum_h_2 in_10 vref -2.547806e-6
Gw1_11_2 0 sum_h_2 in_11 vref -5.534774e-6
Gw1_12_2 0 sum_h_2 in_12 vref -4.372263e-6
Gw1_13_2 0 sum_h_2 in_13 vref -2.782760e-6
Gw1_14_2 0 sum_h_2 in_14 vref 3.372571e-6
Gw1_15_2 0 sum_h_2 in_15 vref 2.618354e-7
Gw1_16_2 0 sum_h_2 in_16 vref -1.739276e-7
Gw1_17_2 0 sum_h_2 in_17 vref -4.193386e-6
Gw1_18_2 0 sum_h_2 in_18 vref 3.203375e-6
Gw1_19_2 0 sum_h_2 in_19 vref 4.436218e-6
Gw1_20_2 0 sum_h_2 in_20 vref 1.413734e-6
Gw1_21_2 0 sum_h_2 in_21 vref 2.088003e-7
Gw1_22_2 0 sum_h_2 in_22 vref -1.604358e-6
Gw1_23_2 0 sum_h_2 in_23 vref 2.219370e-6
Gw1_24_2 0 sum_h_2 in_24 vref -6.917350e-6
Gw1_25_2 0 sum_h_2 in_25 vref 4.728736e-6
Gw1_26_2 0 sum_h_2 in_26 vref 1.960032e-6
Gw1_27_2 0 sum_h_2 in_27 vref 4.913165e-6
Gw1_28_2 0 sum_h_2 in_28 vref 8.787501e-7
Gw1_29_2 0 sum_h_2 in_29 vref 2.258084e-6
Gw1_30_2 0 sum_h_2 in_30 vref -7.993811e-6
Gw1_31_2 0 sum_h_2 in_31 vref 6.606850e-7
Gw1_32_2 0 sum_h_2 in_32 vref 3.418504e-6
Gw1_33_2 0 sum_h_2 in_33 vref 1.317036e-6
Gw1_34_2 0 sum_h_2 in_34 vref 9.847328e-7
Gw1_35_2 0 sum_h_2 in_35 vref -1.695208e-6
Gw1_36_2 0 sum_h_2 in_36 vref 1.052626e-6
Gw1_37_2 0 sum_h_2 in_37 vref -2.934064e-7
Gw1_38_2 0 sum_h_2 in_38 vref 2.726880e-6
Gw1_39_2 0 sum_h_2 in_39 vref -1.879334e-6
Gw1_40_2 0 sum_h_2 in_40 vref -3.617140e-6
Gw1_41_2 0 sum_h_2 in_41 vref -3.377791e-6
Gw1_42_2 0 sum_h_2 in_42 vref -3.084317e-6
Gw1_43_2 0 sum_h_2 in_43 vref 1.369812e-6
Gw1_44_2 0 sum_h_2 in_44 vref 2.352958e-6
Gw1_45_2 0 sum_h_2 in_45 vref -1.899005e-6
Gw1_46_2 0 sum_h_2 in_46 vref -2.451598e-6
Gw1_47_2 0 sum_h_2 in_47 vref 6.682338e-8
Gw1_48_2 0 sum_h_2 in_48 vref 2.812016e-6
Gw1_0_3 0 sum_h_3 in_0 vref 3.266646e-7
Gw1_1_3 0 sum_h_3 in_1 vref 1.933457e-7
Gw1_2_3 0 sum_h_3 in_2 vref 3.631867e-6
Gw1_3_3 0 sum_h_3 in_3 vref 7.163858e-8
Gw1_4_3 0 sum_h_3 in_4 vref 3.825465e-6
Gw1_5_3 0 sum_h_3 in_5 vref 2.779644e-6
Gw1_6_3 0 sum_h_3 in_6 vref -3.266629e-6
Gw1_7_3 0 sum_h_3 in_7 vref -6.197563e-7
Gw1_8_3 0 sum_h_3 in_8 vref -1.150517e-6
Gw1_9_3 0 sum_h_3 in_9 vref -4.875297e-7
Gw1_10_3 0 sum_h_3 in_10 vref 3.514242e-7
Gw1_11_3 0 sum_h_3 in_11 vref 2.336384e-7
Gw1_12_3 0 sum_h_3 in_12 vref -1.614810e-6
Gw1_13_3 0 sum_h_3 in_13 vref -5.914896e-6
Gw1_14_3 0 sum_h_3 in_14 vref -1.529737e-6
Gw1_15_3 0 sum_h_3 in_15 vref -4.671018e-7
Gw1_16_3 0 sum_h_3 in_16 vref -1.034346e-6
Gw1_17_3 0 sum_h_3 in_17 vref -2.281169e-6
Gw1_18_3 0 sum_h_3 in_18 vref -2.521410e-6
Gw1_19_3 0 sum_h_3 in_19 vref -2.305080e-7
Gw1_20_3 0 sum_h_3 in_20 vref -8.583601e-6
Gw1_21_3 0 sum_h_3 in_21 vref -2.808465e-7
Gw1_22_3 0 sum_h_3 in_22 vref 4.477453e-7
Gw1_23_3 0 sum_h_3 in_23 vref 1.345310e-6
Gw1_24_3 0 sum_h_3 in_24 vref -3.661939e-6
Gw1_25_3 0 sum_h_3 in_25 vref -3.030713e-7
Gw1_26_3 0 sum_h_3 in_26 vref 1.958127e-6
Gw1_27_3 0 sum_h_3 in_27 vref 7.411336e-7
Gw1_28_3 0 sum_h_3 in_28 vref -3.158785e-6
Gw1_29_3 0 sum_h_3 in_29 vref 2.517338e-6
Gw1_30_3 0 sum_h_3 in_30 vref 5.358714e-6
Gw1_31_3 0 sum_h_3 in_31 vref 1.508717e-6
Gw1_32_3 0 sum_h_3 in_32 vref 2.676564e-6
Gw1_33_3 0 sum_h_3 in_33 vref 6.683439e-7
Gw1_34_3 0 sum_h_3 in_34 vref 2.924812e-6
Gw1_35_3 0 sum_h_3 in_35 vref -8.574660e-7
Gw1_36_3 0 sum_h_3 in_36 vref 7.563283e-8
Gw1_37_3 0 sum_h_3 in_37 vref 7.023386e-7
Gw1_38_3 0 sum_h_3 in_38 vref 1.730709e-6
Gw1_39_3 0 sum_h_3 in_39 vref 8.284223e-7
Gw1_40_3 0 sum_h_3 in_40 vref 2.619271e-6
Gw1_41_3 0 sum_h_3 in_41 vref 1.368073e-6
Gw1_42_3 0 sum_h_3 in_42 vref -3.039902e-6
Gw1_43_3 0 sum_h_3 in_43 vref -2.291544e-6
Gw1_44_3 0 sum_h_3 in_44 vref -2.638267e-6
Gw1_45_3 0 sum_h_3 in_45 vref -3.689399e-6
Gw1_46_3 0 sum_h_3 in_46 vref -3.372287e-6
Gw1_47_3 0 sum_h_3 in_47 vref 1.962594e-6
Gw1_48_3 0 sum_h_3 in_48 vref -8.488440e-7
Gw1_0_4 0 sum_h_4 in_0 vref 1.735679e-6
Gw1_1_4 0 sum_h_4 in_1 vref -3.670606e-6
Gw1_2_4 0 sum_h_4 in_2 vref 1.839018e-7
Gw1_3_4 0 sum_h_4 in_3 vref 1.889488e-6
Gw1_4_4 0 sum_h_4 in_4 vref 1.902596e-6
Gw1_5_4 0 sum_h_4 in_5 vref -2.312992e-6
Gw1_6_4 0 sum_h_4 in_6 vref 6.931714e-7
Gw1_7_4 0 sum_h_4 in_7 vref 2.302003e-6
Gw1_8_4 0 sum_h_4 in_8 vref 1.187951e-6
Gw1_9_4 0 sum_h_4 in_9 vref 7.433774e-7
Gw1_10_4 0 sum_h_4 in_10 vref 4.727311e-7
Gw1_11_4 0 sum_h_4 in_11 vref -2.130961e-6
Gw1_12_4 0 sum_h_4 in_12 vref -5.564726e-6
Gw1_13_4 0 sum_h_4 in_13 vref -1.985061e-6
Gw1_14_4 0 sum_h_4 in_14 vref 4.998498e-7
Gw1_15_4 0 sum_h_4 in_15 vref 1.757621e-6
Gw1_16_4 0 sum_h_4 in_16 vref -1.285838e-6
Gw1_17_4 0 sum_h_4 in_17 vref 5.039156e-6
Gw1_18_4 0 sum_h_4 in_18 vref -1.160176e-6
Gw1_19_4 0 sum_h_4 in_19 vref -3.155416e-6
Gw1_20_4 0 sum_h_4 in_20 vref -5.947541e-6
Gw1_21_4 0 sum_h_4 in_21 vref -3.100946e-7
Gw1_22_4 0 sum_h_4 in_22 vref -6.043944e-7
Gw1_23_4 0 sum_h_4 in_23 vref 8.743133e-7
Gw1_24_4 0 sum_h_4 in_24 vref 4.408166e-7
Gw1_25_4 0 sum_h_4 in_25 vref 1.848798e-6
Gw1_26_4 0 sum_h_4 in_26 vref 3.787714e-6
Gw1_27_4 0 sum_h_4 in_27 vref -1.387366e-6
Gw1_28_4 0 sum_h_4 in_28 vref -1.559039e-6
Gw1_29_4 0 sum_h_4 in_29 vref 7.118233e-8
Gw1_30_4 0 sum_h_4 in_30 vref -8.674428e-7
Gw1_31_4 0 sum_h_4 in_31 vref -2.077657e-6
Gw1_32_4 0 sum_h_4 in_32 vref 8.828067e-7
Gw1_33_4 0 sum_h_4 in_33 vref 1.226315e-6
Gw1_34_4 0 sum_h_4 in_34 vref -5.036764e-6
Gw1_35_4 0 sum_h_4 in_35 vref 5.536164e-7
Gw1_36_4 0 sum_h_4 in_36 vref -5.922636e-6
Gw1_37_4 0 sum_h_4 in_37 vref -4.101056e-6
Gw1_38_4 0 sum_h_4 in_38 vref 8.303797e-7
Gw1_39_4 0 sum_h_4 in_39 vref -2.015219e-6
Gw1_40_4 0 sum_h_4 in_40 vref -5.653289e-6
Gw1_41_4 0 sum_h_4 in_41 vref -2.944416e-6
Gw1_42_4 0 sum_h_4 in_42 vref -1.143947e-6
Gw1_43_4 0 sum_h_4 in_43 vref -9.013542e-7
Gw1_44_4 0 sum_h_4 in_44 vref 7.464109e-7
Gw1_45_4 0 sum_h_4 in_45 vref 4.239108e-6
Gw1_46_4 0 sum_h_4 in_46 vref 3.585817e-7
Gw1_47_4 0 sum_h_4 in_47 vref 3.366551e-6
Gw1_48_4 0 sum_h_4 in_48 vref 1.473535e-6
Gw1_0_5 0 sum_h_5 in_0 vref -1.315285e-6
Gw1_1_5 0 sum_h_5 in_1 vref -2.816806e-6
Gw1_2_5 0 sum_h_5 in_2 vref -3.639213e-6
Gw1_3_5 0 sum_h_5 in_3 vref -3.429869e-6
Gw1_4_5 0 sum_h_5 in_4 vref -5.286872e-6
Gw1_5_5 0 sum_h_5 in_5 vref -1.328482e-6
Gw1_6_5 0 sum_h_5 in_6 vref -5.238443e-6
Gw1_7_5 0 sum_h_5 in_7 vref -3.495434e-6
Gw1_8_5 0 sum_h_5 in_8 vref 3.177176e-8
Gw1_9_5 0 sum_h_5 in_9 vref 2.151464e-6
Gw1_10_5 0 sum_h_5 in_10 vref 2.714881e-6
Gw1_11_5 0 sum_h_5 in_11 vref 1.731273e-6
Gw1_12_5 0 sum_h_5 in_12 vref -2.945053e-7
Gw1_13_5 0 sum_h_5 in_13 vref 1.015757e-7
Gw1_14_5 0 sum_h_5 in_14 vref -1.167974e-6
Gw1_15_5 0 sum_h_5 in_15 vref 3.750644e-6
Gw1_16_5 0 sum_h_5 in_16 vref 2.537947e-6
Gw1_17_5 0 sum_h_5 in_17 vref 3.225237e-6
Gw1_18_5 0 sum_h_5 in_18 vref 1.710301e-6
Gw1_19_5 0 sum_h_5 in_19 vref 3.646545e-6
Gw1_20_5 0 sum_h_5 in_20 vref 3.376871e-6
Gw1_21_5 0 sum_h_5 in_21 vref -3.637819e-6
Gw1_22_5 0 sum_h_5 in_22 vref -3.266689e-6
Gw1_23_5 0 sum_h_5 in_23 vref -7.338283e-7
Gw1_24_5 0 sum_h_5 in_24 vref -3.329237e-6
Gw1_25_5 0 sum_h_5 in_25 vref -1.287090e-6
Gw1_26_5 0 sum_h_5 in_26 vref 1.626447e-7
Gw1_27_5 0 sum_h_5 in_27 vref 1.770594e-6
Gw1_28_5 0 sum_h_5 in_28 vref -2.936496e-6
Gw1_29_5 0 sum_h_5 in_29 vref 9.964664e-7
Gw1_30_5 0 sum_h_5 in_30 vref -1.034748e-8
Gw1_31_5 0 sum_h_5 in_31 vref -3.066016e-6
Gw1_32_5 0 sum_h_5 in_32 vref 2.894334e-7
Gw1_33_5 0 sum_h_5 in_33 vref 4.193744e-7
Gw1_34_5 0 sum_h_5 in_34 vref 8.581360e-7
Gw1_35_5 0 sum_h_5 in_35 vref -2.468571e-7
Gw1_36_5 0 sum_h_5 in_36 vref 1.157686e-6
Gw1_37_5 0 sum_h_5 in_37 vref 7.885694e-7
Gw1_38_5 0 sum_h_5 in_38 vref 1.878458e-7
Gw1_39_5 0 sum_h_5 in_39 vref -1.431731e-6
Gw1_40_5 0 sum_h_5 in_40 vref -7.436095e-8
Gw1_41_5 0 sum_h_5 in_41 vref -3.781167e-6
Gw1_42_5 0 sum_h_5 in_42 vref 6.561352e-7
Gw1_43_5 0 sum_h_5 in_43 vref -1.641953e-6
Gw1_44_5 0 sum_h_5 in_44 vref 2.981521e-6
Gw1_45_5 0 sum_h_5 in_45 vref 5.190703e-6
Gw1_46_5 0 sum_h_5 in_46 vref 2.517321e-6
Gw1_47_5 0 sum_h_5 in_47 vref -1.893893e-6
Gw1_48_5 0 sum_h_5 in_48 vref -2.446498e-6
Gw1_0_6 0 sum_h_6 in_0 vref -4.177973e-6
Gw1_1_6 0 sum_h_6 in_1 vref -1.119779e-6
Gw1_2_6 0 sum_h_6 in_2 vref 1.540797e-6
Gw1_3_6 0 sum_h_6 in_3 vref 3.276333e-7
Gw1_4_6 0 sum_h_6 in_4 vref -6.793122e-7
Gw1_5_6 0 sum_h_6 in_5 vref -1.577770e-6
Gw1_6_6 0 sum_h_6 in_6 vref -2.885575e-7
Gw1_7_6 0 sum_h_6 in_7 vref -4.671377e-6
Gw1_8_6 0 sum_h_6 in_8 vref 1.485264e-6
Gw1_9_6 0 sum_h_6 in_9 vref 1.623489e-6
Gw1_10_6 0 sum_h_6 in_10 vref 4.096688e-6
Gw1_11_6 0 sum_h_6 in_11 vref 4.225942e-6
Gw1_12_6 0 sum_h_6 in_12 vref -1.395350e-6
Gw1_13_6 0 sum_h_6 in_13 vref -8.134519e-7
Gw1_14_6 0 sum_h_6 in_14 vref 1.546752e-7
Gw1_15_6 0 sum_h_6 in_15 vref -2.741743e-6
Gw1_16_6 0 sum_h_6 in_16 vref -2.516439e-6
Gw1_17_6 0 sum_h_6 in_17 vref -2.911823e-6
Gw1_18_6 0 sum_h_6 in_18 vref 2.982314e-6
Gw1_19_6 0 sum_h_6 in_19 vref 1.836337e-6
Gw1_20_6 0 sum_h_6 in_20 vref -8.150882e-6
Gw1_21_6 0 sum_h_6 in_21 vref 1.226276e-6
Gw1_22_6 0 sum_h_6 in_22 vref -8.839552e-7
Gw1_23_6 0 sum_h_6 in_23 vref -5.343647e-7
Gw1_24_6 0 sum_h_6 in_24 vref -5.074482e-7
Gw1_25_6 0 sum_h_6 in_25 vref 2.982761e-6
Gw1_26_6 0 sum_h_6 in_26 vref -1.927910e-6
Gw1_27_6 0 sum_h_6 in_27 vref 3.590159e-7
Gw1_28_6 0 sum_h_6 in_28 vref 1.285084e-6
Gw1_29_6 0 sum_h_6 in_29 vref 1.304289e-6
Gw1_30_6 0 sum_h_6 in_30 vref -3.648277e-6
Gw1_31_6 0 sum_h_6 in_31 vref -2.012331e-6
Gw1_32_6 0 sum_h_6 in_32 vref 2.505334e-6
Gw1_33_6 0 sum_h_6 in_33 vref 1.374691e-6
Gw1_34_6 0 sum_h_6 in_34 vref -4.714193e-6
Gw1_35_6 0 sum_h_6 in_35 vref 2.839582e-6
Gw1_36_6 0 sum_h_6 in_36 vref 1.532490e-6
Gw1_37_6 0 sum_h_6 in_37 vref -1.278026e-6
Gw1_38_6 0 sum_h_6 in_38 vref -2.206481e-6
Gw1_39_6 0 sum_h_6 in_39 vref -3.881615e-7
Gw1_40_6 0 sum_h_6 in_40 vref 3.837538e-7
Gw1_41_6 0 sum_h_6 in_41 vref 1.769217e-6
Gw1_42_6 0 sum_h_6 in_42 vref 3.126116e-7
Gw1_43_6 0 sum_h_6 in_43 vref 3.724944e-6
Gw1_44_6 0 sum_h_6 in_44 vref 8.377524e-6
Gw1_45_6 0 sum_h_6 in_45 vref -2.594893e-6
Gw1_46_6 0 sum_h_6 in_46 vref 1.333778e-6
Gw1_47_6 0 sum_h_6 in_47 vref 2.809634e-6
Gw1_48_6 0 sum_h_6 in_48 vref -7.764048e-7
Gw1_0_7 0 sum_h_7 in_0 vref -5.228190e-7
Gw1_1_7 0 sum_h_7 in_1 vref -3.368323e-6
Gw1_2_7 0 sum_h_7 in_2 vref -3.025983e-6
Gw1_3_7 0 sum_h_7 in_3 vref 2.646132e-6
Gw1_4_7 0 sum_h_7 in_4 vref 5.835383e-6
Gw1_5_7 0 sum_h_7 in_5 vref 1.907667e-6
Gw1_6_7 0 sum_h_7 in_6 vref 2.265485e-6
Gw1_7_7 0 sum_h_7 in_7 vref -4.505304e-6
Gw1_8_7 0 sum_h_7 in_8 vref -2.871826e-6
Gw1_9_7 0 sum_h_7 in_9 vref -7.884179e-7
Gw1_10_7 0 sum_h_7 in_10 vref 1.367534e-6
Gw1_11_7 0 sum_h_7 in_11 vref 3.571510e-6
Gw1_12_7 0 sum_h_7 in_12 vref 3.600548e-6
Gw1_13_7 0 sum_h_7 in_13 vref 2.545272e-6
Gw1_14_7 0 sum_h_7 in_14 vref 1.655310e-6
Gw1_15_7 0 sum_h_7 in_15 vref -1.075704e-6
Gw1_16_7 0 sum_h_7 in_16 vref 1.434568e-6
Gw1_17_7 0 sum_h_7 in_17 vref -1.070137e-6
Gw1_18_7 0 sum_h_7 in_18 vref -7.270453e-6
Gw1_19_7 0 sum_h_7 in_19 vref -8.972816e-6
Gw1_20_7 0 sum_h_7 in_20 vref -4.433129e-6
Gw1_21_7 0 sum_h_7 in_21 vref -1.844629e-6
Gw1_22_7 0 sum_h_7 in_22 vref 1.428415e-6
Gw1_23_7 0 sum_h_7 in_23 vref -6.055878e-7
Gw1_24_7 0 sum_h_7 in_24 vref 2.843213e-8
Gw1_25_7 0 sum_h_7 in_25 vref 2.381344e-6
Gw1_26_7 0 sum_h_7 in_26 vref 8.028249e-7
Gw1_27_7 0 sum_h_7 in_27 vref -1.063741e-8
Gw1_28_7 0 sum_h_7 in_28 vref -2.555673e-6
Gw1_29_7 0 sum_h_7 in_29 vref -1.708135e-6
Gw1_30_7 0 sum_h_7 in_30 vref 1.904206e-8
Gw1_31_7 0 sum_h_7 in_31 vref -5.713593e-7
Gw1_32_7 0 sum_h_7 in_32 vref 1.062573e-6
Gw1_33_7 0 sum_h_7 in_33 vref 3.409025e-7
Gw1_34_7 0 sum_h_7 in_34 vref -3.937225e-7
Gw1_35_7 0 sum_h_7 in_35 vref 1.228414e-6
Gw1_36_7 0 sum_h_7 in_36 vref -4.194200e-7
Gw1_37_7 0 sum_h_7 in_37 vref -5.672906e-7
Gw1_38_7 0 sum_h_7 in_38 vref 1.627586e-6
Gw1_39_7 0 sum_h_7 in_39 vref -7.760713e-8
Gw1_40_7 0 sum_h_7 in_40 vref 1.105818e-6
Gw1_41_7 0 sum_h_7 in_41 vref 8.629790e-7
Gw1_42_7 0 sum_h_7 in_42 vref -3.582504e-7
Gw1_43_7 0 sum_h_7 in_43 vref -2.070083e-6
Gw1_44_7 0 sum_h_7 in_44 vref 1.267529e-6
Gw1_45_7 0 sum_h_7 in_45 vref 1.771966e-6
Gw1_46_7 0 sum_h_7 in_46 vref 4.022873e-6
Gw1_47_7 0 sum_h_7 in_47 vref -4.709635e-7
Gw1_48_7 0 sum_h_7 in_48 vref -2.140855e-6
Gw1_0_8 0 sum_h_8 in_0 vref -5.146418e-6
Gw1_1_8 0 sum_h_8 in_1 vref -5.895476e-6
Gw1_2_8 0 sum_h_8 in_2 vref -1.395325e-7
Gw1_3_8 0 sum_h_8 in_3 vref 1.465668e-6
Gw1_4_8 0 sum_h_8 in_4 vref -1.610914e-6
Gw1_5_8 0 sum_h_8 in_5 vref 7.270590e-7
Gw1_6_8 0 sum_h_8 in_6 vref -3.744530e-7
Gw1_7_8 0 sum_h_8 in_7 vref 4.289305e-7
Gw1_8_8 0 sum_h_8 in_8 vref 2.630867e-7
Gw1_9_8 0 sum_h_8 in_9 vref 1.163240e-6
Gw1_10_8 0 sum_h_8 in_10 vref -2.198043e-6
Gw1_11_8 0 sum_h_8 in_11 vref -2.029236e-6
Gw1_12_8 0 sum_h_8 in_12 vref 8.927915e-8
Gw1_13_8 0 sum_h_8 in_13 vref 5.455039e-6
Gw1_14_8 0 sum_h_8 in_14 vref -4.134318e-6
Gw1_15_8 0 sum_h_8 in_15 vref 3.748651e-7
Gw1_16_8 0 sum_h_8 in_16 vref -2.943563e-6
Gw1_17_8 0 sum_h_8 in_17 vref -3.580364e-7
Gw1_18_8 0 sum_h_8 in_18 vref -4.626574e-7
Gw1_19_8 0 sum_h_8 in_19 vref -1.566526e-7
Gw1_20_8 0 sum_h_8 in_20 vref 5.052740e-6
Gw1_21_8 0 sum_h_8 in_21 vref -6.074385e-6
Gw1_22_8 0 sum_h_8 in_22 vref -2.066687e-6
Gw1_23_8 0 sum_h_8 in_23 vref 4.389445e-6
Gw1_24_8 0 sum_h_8 in_24 vref 4.853464e-7
Gw1_25_8 0 sum_h_8 in_25 vref -1.639354e-6
Gw1_26_8 0 sum_h_8 in_26 vref 1.606682e-7
Gw1_27_8 0 sum_h_8 in_27 vref 1.193122e-6
Gw1_28_8 0 sum_h_8 in_28 vref -3.267400e-6
Gw1_29_8 0 sum_h_8 in_29 vref 2.742428e-6
Gw1_30_8 0 sum_h_8 in_30 vref -2.149326e-6
Gw1_31_8 0 sum_h_8 in_31 vref -3.494136e-6
Gw1_32_8 0 sum_h_8 in_32 vref 2.758281e-6
Gw1_33_8 0 sum_h_8 in_33 vref 3.029188e-6
Gw1_34_8 0 sum_h_8 in_34 vref -2.980578e-6
Gw1_35_8 0 sum_h_8 in_35 vref 4.227064e-7
Gw1_36_8 0 sum_h_8 in_36 vref 1.541992e-6
Gw1_37_8 0 sum_h_8 in_37 vref 1.577682e-6
Gw1_38_8 0 sum_h_8 in_38 vref 3.205142e-6
Gw1_39_8 0 sum_h_8 in_39 vref 2.237481e-6
Gw1_40_8 0 sum_h_8 in_40 vref -1.744146e-6
Gw1_41_8 0 sum_h_8 in_41 vref -2.838504e-6
Gw1_42_8 0 sum_h_8 in_42 vref -5.577831e-6
Gw1_43_8 0 sum_h_8 in_43 vref -1.980100e-6
Gw1_44_8 0 sum_h_8 in_44 vref 4.608646e-7
Gw1_45_8 0 sum_h_8 in_45 vref 1.036910e-6
Gw1_46_8 0 sum_h_8 in_46 vref -3.577566e-6
Gw1_47_8 0 sum_h_8 in_47 vref -4.715851e-6
Gw1_48_8 0 sum_h_8 in_48 vref -6.075061e-6

* Hidden layer bias currents
Ib1_0 0 sum_h_0 DC 2.603814e-6
Ib1_1 0 sum_h_1 DC -1.995789e-6
Ib1_2 0 sum_h_2 DC 3.831697e-6
Ib1_3 0 sum_h_3 DC 1.805005e-6
Ib1_4 0 sum_h_4 DC -2.869316e-6
Ib1_5 0 sum_h_5 DC -1.529773e-6
Ib1_6 0 sum_h_6 DC 4.853796e-6
Ib1_7 0 sum_h_7 DC -2.131114e-6
Ib1_8 0 sum_h_8 DC -6.132510e-8

* ========== Output Layer Neurons ==========
Xo_0 mem_o_0 vref vdd pulse_o_0 sum_o_0 lif_neuron
Xo_1 mem_o_1 vref vdd pulse_o_1 sum_o_1 lif_neuron
Xo_2 mem_o_2 vref vdd pulse_o_2 sum_o_2 lif_neuron
Xo_3 mem_o_3 vref vdd pulse_o_3 sum_o_3 lif_neuron
Xo_4 mem_o_4 vref vdd pulse_o_4 sum_o_4 lif_neuron
Xo_5 mem_o_5 vref vdd pulse_o_5 sum_o_5 lif_neuron
Xo_6 mem_o_6 vref vdd pulse_o_6 sum_o_6 lif_neuron
Xo_7 mem_o_7 vref vdd pulse_o_7 sum_o_7 lif_neuron
Xo_8 mem_o_8 vref vdd pulse_o_8 sum_o_8 lif_neuron
Xo_9 mem_o_9 vref vdd pulse_o_9 sum_o_9 lif_neuron

* ========== Hidden -> Output Synapses (VCCS) ==========
* Uses stretched pulse output (pulse_h_*) for better charge transfer
Gw2_0_0 0 sum_o_0 pulse_h_0 0 -1.193462e-6
Gw2_1_0 0 sum_o_0 pulse_h_1 0 -5.019219e-7
Gw2_2_0 0 sum_o_0 pulse_h_2 0 -1.128119e-6
Gw2_3_0 0 sum_o_0 pulse_h_3 0 1.069905e-6
Gw2_4_0 0 sum_o_0 pulse_h_4 0 -1.371957e-6
Gw2_5_0 0 sum_o_0 pulse_h_5 0 1.711180e-6
Gw2_6_0 0 sum_o_0 pulse_h_6 0 -1.615697e-7
Gw2_7_0 0 sum_o_0 pulse_h_7 0 -2.165169e-7
Gw2_8_0 0 sum_o_0 pulse_h_8 0 1.837948e-6
Gw2_0_1 0 sum_o_1 pulse_h_0 0 1.717746e-6
Gw2_1_1 0 sum_o_1 pulse_h_1 0 -1.769480e-6
Gw2_2_1 0 sum_o_1 pulse_h_2 0 -1.795199e-6
Gw2_3_1 0 sum_o_1 pulse_h_3 0 -4.359422e-6
Gw2_4_1 0 sum_o_1 pulse_h_4 0 5.485386e-7
Gw2_5_1 0 sum_o_1 pulse_h_5 0 -5.661966e-6
Gw2_6_1 0 sum_o_1 pulse_h_6 0 -1.133445e-6
Gw2_7_1 0 sum_o_1 pulse_h_7 0 -6.104438e-7
Gw2_8_1 0 sum_o_1 pulse_h_8 0 -9.236622e-7
Gw2_0_2 0 sum_o_2 pulse_h_0 0 1.548742e-6
Gw2_1_2 0 sum_o_2 pulse_h_1 0 -1.049368e-6
Gw2_2_2 0 sum_o_2 pulse_h_2 0 -1.018466e-7
Gw2_3_2 0 sum_o_2 pulse_h_3 0 6.443562e-7
Gw2_4_2 0 sum_o_2 pulse_h_4 0 -4.432450e-7
Gw2_5_2 0 sum_o_2 pulse_h_5 0 -3.940979e-7
Gw2_6_2 0 sum_o_2 pulse_h_6 0 1.366679e-7
Gw2_7_2 0 sum_o_2 pulse_h_7 0 -1.860649e-6
Gw2_8_2 0 sum_o_2 pulse_h_8 0 3.620093e-8
Gw2_0_3 0 sum_o_3 pulse_h_0 0 1.012437e-6
Gw2_1_3 0 sum_o_3 pulse_h_1 0 -6.860329e-7
Gw2_2_3 0 sum_o_3 pulse_h_2 0 -1.401661e-6
Gw2_3_3 0 sum_o_3 pulse_h_3 0 -1.436897e-6
Gw2_4_3 0 sum_o_3 pulse_h_4 0 4.264041e-7
Gw2_5_3 0 sum_o_3 pulse_h_5 0 2.397941e-7
Gw2_6_3 0 sum_o_3 pulse_h_6 0 1.295974e-6
Gw2_7_3 0 sum_o_3 pulse_h_7 0 -3.474798e-7
Gw2_8_3 0 sum_o_3 pulse_h_8 0 1.455790e-6
Gw2_0_4 0 sum_o_4 pulse_h_0 0 -3.051498e-6
Gw2_1_4 0 sum_o_4 pulse_h_1 0 1.797093e-6
Gw2_2_4 0 sum_o_4 pulse_h_2 0 -5.110400e-8
Gw2_3_4 0 sum_o_4 pulse_h_3 0 1.326716e-6
Gw2_4_4 0 sum_o_4 pulse_h_4 0 -5.031115e-7
Gw2_5_4 0 sum_o_4 pulse_h_5 0 -3.775063e-6
Gw2_6_4 0 sum_o_4 pulse_h_6 0 -2.315575e-7
Gw2_7_4 0 sum_o_4 pulse_h_7 0 -1.838530e-6
Gw2_8_4 0 sum_o_4 pulse_h_8 0 1.194779e-6
Gw2_0_5 0 sum_o_5 pulse_h_0 0 -2.759004e-7
Gw2_1_5 0 sum_o_5 pulse_h_1 0 -7.568504e-8
Gw2_2_5 0 sum_o_5 pulse_h_2 0 -1.484873e-6
Gw2_3_5 0 sum_o_5 pulse_h_3 0 -1.253981e-6
Gw2_4_5 0 sum_o_5 pulse_h_4 0 -1.784629e-6
Gw2_5_5 0 sum_o_5 pulse_h_5 0 4.950940e-7
Gw2_6_5 0 sum_o_5 pulse_h_6 0 -7.644659e-7
Gw2_7_5 0 sum_o_5 pulse_h_7 0 2.227199e-6
Gw2_8_5 0 sum_o_5 pulse_h_8 0 1.920447e-6
Gw2_0_6 0 sum_o_6 pulse_h_0 0 2.917419e-7
Gw2_1_6 0 sum_o_6 pulse_h_1 0 1.332636e-7
Gw2_2_6 0 sum_o_6 pulse_h_2 0 5.656294e-7
Gw2_3_6 0 sum_o_6 pulse_h_3 0 1.522543e-6
Gw2_4_6 0 sum_o_6 pulse_h_4 0 -5.179057e-7
Gw2_5_6 0 sum_o_6 pulse_h_5 0 -2.202195e-6
Gw2_6_6 0 sum_o_6 pulse_h_6 0 -3.192841e-6
Gw2_7_6 0 sum_o_6 pulse_h_7 0 1.483856e-6
Gw2_8_6 0 sum_o_6 pulse_h_8 0 1.546044e-6
Gw2_0_7 0 sum_o_7 pulse_h_0 0 -8.519156e-7
Gw2_1_7 0 sum_o_7 pulse_h_1 0 -6.173091e-7
Gw2_2_7 0 sum_o_7 pulse_h_2 0 6.843606e-7
Gw2_3_7 0 sum_o_7 pulse_h_3 0 -1.308713e-6
Gw2_4_7 0 sum_o_7 pulse_h_4 0 1.110757e-6
Gw2_5_7 0 sum_o_7 pulse_h_5 0 6.367686e-7
Gw2_6_7 0 sum_o_7 pulse_h_6 0 2.271505e-7
Gw2_7_7 0 sum_o_7 pulse_h_7 0 2.665412e-7
Gw2_8_7 0 sum_o_7 pulse_h_8 0 -1.566821e-6
Gw2_0_8 0 sum_o_8 pulse_h_0 0 1.031773e-6
Gw2_1_8 0 sum_o_8 pulse_h_1 0 1.260646e-6
Gw2_2_8 0 sum_o_8 pulse_h_2 0 -1.218692e-6
Gw2_3_8 0 sum_o_8 pulse_h_3 0 -5.960285e-7
Gw2_4_8 0 sum_o_8 pulse_h_4 0 -2.018979e-6
Gw2_5_8 0 sum_o_8 pulse_h_5 0 3.167067e-7
Gw2_6_8 0 sum_o_8 pulse_h_6 0 -7.427633e-7
Gw2_7_8 0 sum_o_8 pulse_h_7 0 -5.330539e-7
Gw2_8_8 0 sum_o_8 pulse_h_8 0 4.549795e-7
Gw2_0_9 0 sum_o_9 pulse_h_0 0 -2.568316e-6
Gw2_1_9 0 sum_o_9 pulse_h_1 0 1.473087e-6
Gw2_2_9 0 sum_o_9 pulse_h_2 0 -7.088372e-7
Gw2_3_9 0 sum_o_9 pulse_h_3 0 9.870073e-8
Gw2_4_9 0 sum_o_9 pulse_h_4 0 6.603570e-7
Gw2_5_9 0 sum_o_9 pulse_h_5 0 -6.410278e-7
Gw2_6_9 0 sum_o_9 pulse_h_6 0 8.069026e-7
Gw2_7_9 0 sum_o_9 pulse_h_7 0 -1.410349e-8
Gw2_8_9 0 sum_o_9 pulse_h_8 0 -8.380254e-7

* Output layer bias currents
Ib2_0 0 sum_o_0 DC -5.060004e-6
Ib2_1 0 sum_o_1 DC 9.766899e-6
Ib2_2 0 sum_o_2 DC 1.862088e-6
Ib2_3 0 sum_o_3 DC -1.264568e-6
Ib2_4 0 sum_o_4 DC 3.207907e-6
Ib2_5 0 sum_o_5 DC 2.678732e-6
Ib2_6 0 sum_o_6 DC -8.784591e-7
Ib2_7 0 sum_o_7 DC 6.640651e-6
Ib2_8 0 sum_o_8 DC 2.593014e-6
Ib2_9 0 sum_o_9 DC 4.684963e-6

* ========== Simulation ==========
.options reltol=1e-2 abstol=1e-9 vntol=1e-4
.tran 1.000000e-6 2.500000e-2 uic

.control
run
set filetype=ascii
wrdata gilgamesh_output.txt v(pulse_o_0) v(pulse_o_1) v(pulse_o_2) v(pulse_o_3) v(pulse_o_4) v(pulse_o_5) v(pulse_o_6) v(pulse_o_7) v(pulse_o_8) v(pulse_o_9) v(mem_o_0) v(mem_o_1) v(mem_o_2) v(mem_o_3) v(mem_o_4) v(mem_o_5) v(mem_o_6) v(mem_o_7) v(mem_o_8) v(mem_o_9) v(pulse_h_0) v(mem_h_0) v(pulse_h_1) v(mem_h_1) v(pulse_h_2) v(mem_h_2) v(pulse_h_3) v(mem_h_3) v(pulse_h_4) v(mem_h_4) v(pulse_h_5) v(mem_h_5) v(pulse_h_6) v(mem_h_6) v(pulse_h_7) v(mem_h_7) v(pulse_h_8) v(mem_h_8) v(xh_0.comp_out) v(xh_0.vth_node) v(xh_3.comp_raw) v(xh_3.comp_ctrl) v(xh_3.comp_out) v(xh_3.vth_node) v(xo_0.comp_out) v(xo_0.vth_node)
quit
.endc

.end
