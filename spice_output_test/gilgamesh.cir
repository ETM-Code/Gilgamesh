* ================================================================
* gilgamesh SNN - SPICE Simulation (Detailed Pulse-Stretch Model)
* ================================================================
* Architecture: 49 -> 100 -> 10
* Simulation time: 25.00ms
* Membrane: C=1.000e-8F, R=9.491e5Ω, tau=9.49ms
* Pulse stretch: tau=10.00ms (enabled=true)
* Threshold: Vref+0.80V, hysteresis=0.050V
* Analog output: enabled=false

* ========== LIF Neuron Detailed Subcircuit (Pulse Stretching) ==========
* Matches Python reference: lif_neuron_generator_pulse_stretch.py
* Nodes: mem vref vdd comp_pulse analog_out sum
.subckt lif_neuron mem vref vdd comp_pulse analog_out sum

* ---------- Vref buffer (OPA604-like) ----------
Ebuf vref_buf 0 vref 0 1e5
Rbuf vref_buf vref 1k
Cbuf vref 0 80p
Rvr vref vref_buf 1m

* ---------- TIA op-amp with finite gain and compensation ----------
* Inverting integrator: Vmem = gain * (Vref - Vsum)
Eint mem 0 vref sum 2e5
Rout_int mem 0 20
Cint mem 0 5p
Cmem mem sum 1.000e-8
Rleak mem sum 9.491e5
Iint_bias vdd 0 2.000e-5

* ---------- Threshold divider (places threshold near Vref + over_vref) ----------
Rvh vdd vth_node 3.405e6
Rvl vth_node vref 1.580e6
Rf comp_out vth_node 1.068e8

* ---------- Adaptive threshold injection ----------
Cadapt vth_node vref 2.200e-8
.model DADAPT D(Is=1e-6 N=1.05 Rs=2 Cjo=1p Eg=0.69)
Rinj comp_out ninj 2.2Meg
Dinj ninj vth_node DADAPT

* ---------- Soft comparator (deflection space) ----------
.param VLO=0
.param VHI=5
.param VSW=0.01
Bdef vdef 0 V = V(vref) - V(mem)
Btheta_rel vtheta_rel 0 V = V(vth_node) - V(vref)
Bcomp comp_raw 0 V = VLO + (VHI - VLO)*(0.5*(1 + tanh( ( V(vdef) - ( V(vtheta_rel) + 0.003 ) ) / VSW )))
Rcout comp_raw comp_out 1.000e1
Ccout comp_out 0 4.000e-9
Icomp_bias vdd 0 2.000e-6

* ---------- Pulse stretching circuit ----------
* tau_pulse = 1.000e5Ω × 1.000e-7F = 10.00ms
* Diode allows fast charging, slow discharge through Rpw
.model DPW D(Is=1e-12 N=1.05 Rs=10 Cjo=1p)
Dpw comp_out comp_pulse DPW
Rpw comp_pulse 0 1.000e5
Cpw comp_pulse 0 1.000e-7

* ---------- Reset path ----------
Rreset mem reset_node 2.000e2
Coff_reset reset_node vref 7.000e-12
Sreset reset_node vref comp_out 0 SWMUX
.model SWMUX SW(Ron=10 Roff=1.000e9 Vt=2.5 Vh=0.1)

* ---------- Analog output disabled ----------
Rana_tie analog_out vref 1Meg

.ends lif_neuron

* ========== Power Supplies ==========
Vdd vdd 0 DC 5
Vref vref 0 DC 2.5

* ========== Input Voltage Sources ==========
* Inputs scaled to voltage around Vref
Vin_0 in_0 0 DC 2.287894
Vin_1 in_1 0 DC 2.287894
Vin_2 in_2 0 DC 2.287894
Vin_3 in_3 0 DC 2.287894
Vin_4 in_4 0 DC 2.287894
Vin_5 in_5 0 DC 2.287894
Vin_6 in_6 0 DC 2.287894
Vin_7 in_7 0 DC 2.287894
Vin_8 in_8 0 DC 2.394890
Vin_9 in_9 0 DC 2.449383
Vin_10 in_10 0 DC 2.287894
Vin_11 in_11 0 DC 2.287894
Vin_12 in_12 0 DC 2.287894
Vin_13 in_13 0 DC 2.287894
Vin_14 in_14 0 DC 2.287894
Vin_15 in_15 0 DC 2.549220
Vin_16 in_16 0 DC 2.922714
Vin_17 in_17 0 DC 3.000000
Vin_18 in_18 0 DC 3.000000
Vin_19 in_19 0 DC 2.766396
Vin_20 in_20 0 DC 2.287894
Vin_21 in_21 0 DC 2.287894
Vin_22 in_22 0 DC 2.287894
Vin_23 in_23 0 DC 2.287894
Vin_24 in_24 0 DC 2.287894
Vin_25 in_25 0 DC 3.000000
Vin_26 in_26 0 DC 2.338409
Vin_27 in_27 0 DC 2.287894
Vin_28 in_28 0 DC 2.287894
Vin_29 in_29 0 DC 2.287894
Vin_30 in_30 0 DC 2.287894
Vin_31 in_31 0 DC 2.667752
Vin_32 in_32 0 DC 2.848731
Vin_33 in_33 0 DC 2.287894
Vin_34 in_34 0 DC 2.287894
Vin_35 in_35 0 DC 2.287894
Vin_36 in_36 0 DC 2.287894
Vin_37 in_37 0 DC 2.353126
Vin_38 in_38 0 DC 3.000000
Vin_39 in_39 0 DC 2.301815
Vin_40 in_40 0 DC 2.287894
Vin_41 in_41 0 DC 2.287894
Vin_42 in_42 0 DC 2.287894
Vin_43 in_43 0 DC 2.287894
Vin_44 in_44 0 DC 2.706732
Vin_45 in_45 0 DC 2.804183
Vin_46 in_46 0 DC 2.287894
Vin_47 in_47 0 DC 2.287894
Vin_48 in_48 0 DC 2.287894

* ========== Hidden Layer Neurons ==========
Xh_0 mem_h_0 vref vdd pulse_h_0 ana_h_0 sum_h_0 lif_neuron
Xh_1 mem_h_1 vref vdd pulse_h_1 ana_h_1 sum_h_1 lif_neuron
Xh_2 mem_h_2 vref vdd pulse_h_2 ana_h_2 sum_h_2 lif_neuron
Xh_3 mem_h_3 vref vdd pulse_h_3 ana_h_3 sum_h_3 lif_neuron
Xh_4 mem_h_4 vref vdd pulse_h_4 ana_h_4 sum_h_4 lif_neuron
Xh_5 mem_h_5 vref vdd pulse_h_5 ana_h_5 sum_h_5 lif_neuron
Xh_6 mem_h_6 vref vdd pulse_h_6 ana_h_6 sum_h_6 lif_neuron
Xh_7 mem_h_7 vref vdd pulse_h_7 ana_h_7 sum_h_7 lif_neuron
Xh_8 mem_h_8 vref vdd pulse_h_8 ana_h_8 sum_h_8 lif_neuron
Xh_9 mem_h_9 vref vdd pulse_h_9 ana_h_9 sum_h_9 lif_neuron
Xh_10 mem_h_10 vref vdd pulse_h_10 ana_h_10 sum_h_10 lif_neuron
Xh_11 mem_h_11 vref vdd pulse_h_11 ana_h_11 sum_h_11 lif_neuron
Xh_12 mem_h_12 vref vdd pulse_h_12 ana_h_12 sum_h_12 lif_neuron
Xh_13 mem_h_13 vref vdd pulse_h_13 ana_h_13 sum_h_13 lif_neuron
Xh_14 mem_h_14 vref vdd pulse_h_14 ana_h_14 sum_h_14 lif_neuron
Xh_15 mem_h_15 vref vdd pulse_h_15 ana_h_15 sum_h_15 lif_neuron
Xh_16 mem_h_16 vref vdd pulse_h_16 ana_h_16 sum_h_16 lif_neuron
Xh_17 mem_h_17 vref vdd pulse_h_17 ana_h_17 sum_h_17 lif_neuron
Xh_18 mem_h_18 vref vdd pulse_h_18 ana_h_18 sum_h_18 lif_neuron
Xh_19 mem_h_19 vref vdd pulse_h_19 ana_h_19 sum_h_19 lif_neuron
Xh_20 mem_h_20 vref vdd pulse_h_20 ana_h_20 sum_h_20 lif_neuron
Xh_21 mem_h_21 vref vdd pulse_h_21 ana_h_21 sum_h_21 lif_neuron
Xh_22 mem_h_22 vref vdd pulse_h_22 ana_h_22 sum_h_22 lif_neuron
Xh_23 mem_h_23 vref vdd pulse_h_23 ana_h_23 sum_h_23 lif_neuron
Xh_24 mem_h_24 vref vdd pulse_h_24 ana_h_24 sum_h_24 lif_neuron
Xh_25 mem_h_25 vref vdd pulse_h_25 ana_h_25 sum_h_25 lif_neuron
Xh_26 mem_h_26 vref vdd pulse_h_26 ana_h_26 sum_h_26 lif_neuron
Xh_27 mem_h_27 vref vdd pulse_h_27 ana_h_27 sum_h_27 lif_neuron
Xh_28 mem_h_28 vref vdd pulse_h_28 ana_h_28 sum_h_28 lif_neuron
Xh_29 mem_h_29 vref vdd pulse_h_29 ana_h_29 sum_h_29 lif_neuron
Xh_30 mem_h_30 vref vdd pulse_h_30 ana_h_30 sum_h_30 lif_neuron
Xh_31 mem_h_31 vref vdd pulse_h_31 ana_h_31 sum_h_31 lif_neuron
Xh_32 mem_h_32 vref vdd pulse_h_32 ana_h_32 sum_h_32 lif_neuron
Xh_33 mem_h_33 vref vdd pulse_h_33 ana_h_33 sum_h_33 lif_neuron
Xh_34 mem_h_34 vref vdd pulse_h_34 ana_h_34 sum_h_34 lif_neuron
Xh_35 mem_h_35 vref vdd pulse_h_35 ana_h_35 sum_h_35 lif_neuron
Xh_36 mem_h_36 vref vdd pulse_h_36 ana_h_36 sum_h_36 lif_neuron
Xh_37 mem_h_37 vref vdd pulse_h_37 ana_h_37 sum_h_37 lif_neuron
Xh_38 mem_h_38 vref vdd pulse_h_38 ana_h_38 sum_h_38 lif_neuron
Xh_39 mem_h_39 vref vdd pulse_h_39 ana_h_39 sum_h_39 lif_neuron
Xh_40 mem_h_40 vref vdd pulse_h_40 ana_h_40 sum_h_40 lif_neuron
Xh_41 mem_h_41 vref vdd pulse_h_41 ana_h_41 sum_h_41 lif_neuron
Xh_42 mem_h_42 vref vdd pulse_h_42 ana_h_42 sum_h_42 lif_neuron
Xh_43 mem_h_43 vref vdd pulse_h_43 ana_h_43 sum_h_43 lif_neuron
Xh_44 mem_h_44 vref vdd pulse_h_44 ana_h_44 sum_h_44 lif_neuron
Xh_45 mem_h_45 vref vdd pulse_h_45 ana_h_45 sum_h_45 lif_neuron
Xh_46 mem_h_46 vref vdd pulse_h_46 ana_h_46 sum_h_46 lif_neuron
Xh_47 mem_h_47 vref vdd pulse_h_47 ana_h_47 sum_h_47 lif_neuron
Xh_48 mem_h_48 vref vdd pulse_h_48 ana_h_48 sum_h_48 lif_neuron
Xh_49 mem_h_49 vref vdd pulse_h_49 ana_h_49 sum_h_49 lif_neuron
Xh_50 mem_h_50 vref vdd pulse_h_50 ana_h_50 sum_h_50 lif_neuron
Xh_51 mem_h_51 vref vdd pulse_h_51 ana_h_51 sum_h_51 lif_neuron
Xh_52 mem_h_52 vref vdd pulse_h_52 ana_h_52 sum_h_52 lif_neuron
Xh_53 mem_h_53 vref vdd pulse_h_53 ana_h_53 sum_h_53 lif_neuron
Xh_54 mem_h_54 vref vdd pulse_h_54 ana_h_54 sum_h_54 lif_neuron
Xh_55 mem_h_55 vref vdd pulse_h_55 ana_h_55 sum_h_55 lif_neuron
Xh_56 mem_h_56 vref vdd pulse_h_56 ana_h_56 sum_h_56 lif_neuron
Xh_57 mem_h_57 vref vdd pulse_h_57 ana_h_57 sum_h_57 lif_neuron
Xh_58 mem_h_58 vref vdd pulse_h_58 ana_h_58 sum_h_58 lif_neuron
Xh_59 mem_h_59 vref vdd pulse_h_59 ana_h_59 sum_h_59 lif_neuron
Xh_60 mem_h_60 vref vdd pulse_h_60 ana_h_60 sum_h_60 lif_neuron
Xh_61 mem_h_61 vref vdd pulse_h_61 ana_h_61 sum_h_61 lif_neuron
Xh_62 mem_h_62 vref vdd pulse_h_62 ana_h_62 sum_h_62 lif_neuron
Xh_63 mem_h_63 vref vdd pulse_h_63 ana_h_63 sum_h_63 lif_neuron
Xh_64 mem_h_64 vref vdd pulse_h_64 ana_h_64 sum_h_64 lif_neuron
Xh_65 mem_h_65 vref vdd pulse_h_65 ana_h_65 sum_h_65 lif_neuron
Xh_66 mem_h_66 vref vdd pulse_h_66 ana_h_66 sum_h_66 lif_neuron
Xh_67 mem_h_67 vref vdd pulse_h_67 ana_h_67 sum_h_67 lif_neuron
Xh_68 mem_h_68 vref vdd pulse_h_68 ana_h_68 sum_h_68 lif_neuron
Xh_69 mem_h_69 vref vdd pulse_h_69 ana_h_69 sum_h_69 lif_neuron
Xh_70 mem_h_70 vref vdd pulse_h_70 ana_h_70 sum_h_70 lif_neuron
Xh_71 mem_h_71 vref vdd pulse_h_71 ana_h_71 sum_h_71 lif_neuron
Xh_72 mem_h_72 vref vdd pulse_h_72 ana_h_72 sum_h_72 lif_neuron
Xh_73 mem_h_73 vref vdd pulse_h_73 ana_h_73 sum_h_73 lif_neuron
Xh_74 mem_h_74 vref vdd pulse_h_74 ana_h_74 sum_h_74 lif_neuron
Xh_75 mem_h_75 vref vdd pulse_h_75 ana_h_75 sum_h_75 lif_neuron
Xh_76 mem_h_76 vref vdd pulse_h_76 ana_h_76 sum_h_76 lif_neuron
Xh_77 mem_h_77 vref vdd pulse_h_77 ana_h_77 sum_h_77 lif_neuron
Xh_78 mem_h_78 vref vdd pulse_h_78 ana_h_78 sum_h_78 lif_neuron
Xh_79 mem_h_79 vref vdd pulse_h_79 ana_h_79 sum_h_79 lif_neuron
Xh_80 mem_h_80 vref vdd pulse_h_80 ana_h_80 sum_h_80 lif_neuron
Xh_81 mem_h_81 vref vdd pulse_h_81 ana_h_81 sum_h_81 lif_neuron
Xh_82 mem_h_82 vref vdd pulse_h_82 ana_h_82 sum_h_82 lif_neuron
Xh_83 mem_h_83 vref vdd pulse_h_83 ana_h_83 sum_h_83 lif_neuron
Xh_84 mem_h_84 vref vdd pulse_h_84 ana_h_84 sum_h_84 lif_neuron
Xh_85 mem_h_85 vref vdd pulse_h_85 ana_h_85 sum_h_85 lif_neuron
Xh_86 mem_h_86 vref vdd pulse_h_86 ana_h_86 sum_h_86 lif_neuron
Xh_87 mem_h_87 vref vdd pulse_h_87 ana_h_87 sum_h_87 lif_neuron
Xh_88 mem_h_88 vref vdd pulse_h_88 ana_h_88 sum_h_88 lif_neuron
Xh_89 mem_h_89 vref vdd pulse_h_89 ana_h_89 sum_h_89 lif_neuron
Xh_90 mem_h_90 vref vdd pulse_h_90 ana_h_90 sum_h_90 lif_neuron
Xh_91 mem_h_91 vref vdd pulse_h_91 ana_h_91 sum_h_91 lif_neuron
Xh_92 mem_h_92 vref vdd pulse_h_92 ana_h_92 sum_h_92 lif_neuron
Xh_93 mem_h_93 vref vdd pulse_h_93 ana_h_93 sum_h_93 lif_neuron
Xh_94 mem_h_94 vref vdd pulse_h_94 ana_h_94 sum_h_94 lif_neuron
Xh_95 mem_h_95 vref vdd pulse_h_95 ana_h_95 sum_h_95 lif_neuron
Xh_96 mem_h_96 vref vdd pulse_h_96 ana_h_96 sum_h_96 lif_neuron
Xh_97 mem_h_97 vref vdd pulse_h_97 ana_h_97 sum_h_97 lif_neuron
Xh_98 mem_h_98 vref vdd pulse_h_98 ana_h_98 sum_h_98 lif_neuron
Xh_99 mem_h_99 vref vdd pulse_h_99 ana_h_99 sum_h_99 lif_neuron

* ========== Input -> Hidden Synapses (VCCS) ==========
* G<name> n+ n- nc+ nc- transconductance
* Current from n+ to n- = transconductance * (V(nc+) - V(nc-))
Gw1_0_0 0 sum_h_0 in_0 vref 6.555221e-8
Gw1_1_0 0 sum_h_0 in_1 vref 3.382715e-8
Gw1_2_0 0 sum_h_0 in_2 vref -6.327699e-8
Gw1_3_0 0 sum_h_0 in_3 vref 4.505020e-8
Gw1_4_0 0 sum_h_0 in_4 vref -8.979538e-8
Gw1_5_0 0 sum_h_0 in_5 vref 6.621536e-8
Gw1_6_0 0 sum_h_0 in_6 vref -1.550884e-7
Gw1_7_0 0 sum_h_0 in_7 vref -5.446491e-8
Gw1_8_0 0 sum_h_0 in_8 vref -2.090410e-8
Gw1_9_0 0 sum_h_0 in_9 vref -1.391168e-7
Gw1_10_0 0 sum_h_0 in_10 vref 6.290755e-8
Gw1_11_0 0 sum_h_0 in_11 vref 2.928408e-9
Gw1_12_0 0 sum_h_0 in_12 vref -4.508612e-8
Gw1_13_0 0 sum_h_0 in_13 vref 1.012825e-8
Gw1_14_0 0 sum_h_0 in_14 vref 3.590321e-8
Gw1_15_0 0 sum_h_0 in_15 vref -3.100650e-8
Gw1_16_0 0 sum_h_0 in_16 vref -2.896418e-8
Gw1_17_0 0 sum_h_0 in_17 vref -1.620380e-7
Gw1_18_0 0 sum_h_0 in_18 vref 1.834531e-7
Gw1_19_0 0 sum_h_0 in_19 vref -1.106906e-8
Gw1_20_0 0 sum_h_0 in_20 vref -1.693551e-7
Gw1_21_0 0 sum_h_0 in_21 vref 5.707046e-8
Gw1_22_0 0 sum_h_0 in_22 vref 1.310512e-8
Gw1_23_0 0 sum_h_0 in_23 vref -4.145835e-8
Gw1_24_0 0 sum_h_0 in_24 vref 1.005441e-7
Gw1_25_0 0 sum_h_0 in_25 vref -3.988122e-8
Gw1_26_0 0 sum_h_0 in_26 vref -2.191808e-7
Gw1_27_0 0 sum_h_0 in_27 vref -6.818675e-8
Gw1_28_0 0 sum_h_0 in_28 vref -1.087168e-7
Gw1_29_0 0 sum_h_0 in_29 vref 9.160800e-8
Gw1_30_0 0 sum_h_0 in_30 vref -2.798567e-8
Gw1_31_0 0 sum_h_0 in_31 vref 2.898255e-8
Gw1_32_0 0 sum_h_0 in_32 vref 4.146532e-8
Gw1_33_0 0 sum_h_0 in_33 vref 1.586763e-7
Gw1_34_0 0 sum_h_0 in_34 vref 1.356000e-7
Gw1_35_0 0 sum_h_0 in_35 vref 1.397200e-7
Gw1_36_0 0 sum_h_0 in_36 vref 7.315436e-8
Gw1_37_0 0 sum_h_0 in_37 vref 1.442052e-8
Gw1_38_0 0 sum_h_0 in_38 vref -5.380829e-8
Gw1_39_0 0 sum_h_0 in_39 vref 3.196700e-8
Gw1_40_0 0 sum_h_0 in_40 vref 1.940300e-7
Gw1_41_0 0 sum_h_0 in_41 vref -1.334166e-7
Gw1_42_0 0 sum_h_0 in_42 vref 4.501788e-8
Gw1_43_0 0 sum_h_0 in_43 vref -9.961085e-8
Gw1_44_0 0 sum_h_0 in_44 vref 4.404236e-8
Gw1_45_0 0 sum_h_0 in_45 vref 2.399595e-8
Gw1_46_0 0 sum_h_0 in_46 vref -4.342510e-8
Gw1_47_0 0 sum_h_0 in_47 vref 1.494823e-8
Gw1_48_0 0 sum_h_0 in_48 vref -7.848889e-8
Gw1_0_1 0 sum_h_1 in_0 vref -4.884176e-8
Gw1_1_1 0 sum_h_1 in_1 vref -5.088081e-8
Gw1_2_1 0 sum_h_1 in_2 vref 3.363768e-8
Gw1_3_1 0 sum_h_1 in_3 vref -1.311718e-7
Gw1_4_1 0 sum_h_1 in_4 vref 1.508221e-8
Gw1_5_1 0 sum_h_1 in_5 vref -1.085428e-7
Gw1_6_1 0 sum_h_1 in_6 vref 1.150220e-8
Gw1_7_1 0 sum_h_1 in_7 vref 8.061943e-8
Gw1_8_1 0 sum_h_1 in_8 vref -2.720772e-8
Gw1_9_1 0 sum_h_1 in_9 vref 6.602239e-8
Gw1_10_1 0 sum_h_1 in_10 vref 1.584803e-7
Gw1_11_1 0 sum_h_1 in_11 vref -1.691879e-7
Gw1_12_1 0 sum_h_1 in_12 vref -1.699695e-8
Gw1_13_1 0 sum_h_1 in_13 vref -6.155393e-8
Gw1_14_1 0 sum_h_1 in_14 vref -9.986112e-8
Gw1_15_1 0 sum_h_1 in_15 vref 7.245603e-8
Gw1_16_1 0 sum_h_1 in_16 vref -3.131692e-8
Gw1_17_1 0 sum_h_1 in_17 vref -2.482201e-7
Gw1_18_1 0 sum_h_1 in_18 vref 3.342822e-8
Gw1_19_1 0 sum_h_1 in_19 vref -1.234615e-7
Gw1_20_1 0 sum_h_1 in_20 vref 1.349535e-7
Gw1_21_1 0 sum_h_1 in_21 vref 5.396149e-8
Gw1_22_1 0 sum_h_1 in_22 vref 1.176938e-7
Gw1_23_1 0 sum_h_1 in_23 vref 9.622452e-9
Gw1_24_1 0 sum_h_1 in_24 vref -2.861735e-7
Gw1_25_1 0 sum_h_1 in_25 vref -3.785077e-8
Gw1_26_1 0 sum_h_1 in_26 vref -1.487929e-8
Gw1_27_1 0 sum_h_1 in_27 vref 1.497386e-7
Gw1_28_1 0 sum_h_1 in_28 vref 8.803053e-8
Gw1_29_1 0 sum_h_1 in_29 vref -4.012873e-8
Gw1_30_1 0 sum_h_1 in_30 vref 1.340673e-7
Gw1_31_1 0 sum_h_1 in_31 vref -5.405405e-8
Gw1_32_1 0 sum_h_1 in_32 vref 9.381320e-8
Gw1_33_1 0 sum_h_1 in_33 vref 9.839553e-8
Gw1_34_1 0 sum_h_1 in_34 vref -4.485706e-8
Gw1_35_1 0 sum_h_1 in_35 vref 1.456340e-7
Gw1_36_1 0 sum_h_1 in_36 vref -1.879259e-8
Gw1_37_1 0 sum_h_1 in_37 vref 3.511873e-8
Gw1_38_1 0 sum_h_1 in_38 vref 4.153004e-8
Gw1_39_1 0 sum_h_1 in_39 vref 3.457686e-8
Gw1_40_1 0 sum_h_1 in_40 vref -2.934946e-8
Gw1_41_1 0 sum_h_1 in_41 vref -9.992089e-8
Gw1_42_1 0 sum_h_1 in_42 vref 9.408646e-8
Gw1_43_1 0 sum_h_1 in_43 vref 9.678104e-8
Gw1_44_1 0 sum_h_1 in_44 vref -9.276712e-8
Gw1_45_1 0 sum_h_1 in_45 vref 2.177191e-8
Gw1_46_1 0 sum_h_1 in_46 vref -2.427334e-9
Gw1_47_1 0 sum_h_1 in_47 vref -9.939992e-9
Gw1_48_1 0 sum_h_1 in_48 vref 8.514529e-8
Gw1_0_2 0 sum_h_2 in_0 vref 1.126557e-7
Gw1_1_2 0 sum_h_2 in_1 vref -1.532312e-7
Gw1_2_2 0 sum_h_2 in_2 vref -1.624621e-9
Gw1_3_2 0 sum_h_2 in_3 vref 1.191853e-7
Gw1_4_2 0 sum_h_2 in_4 vref -4.786346e-8
Gw1_5_2 0 sum_h_2 in_5 vref -1.376316e-7
Gw1_6_2 0 sum_h_2 in_6 vref 3.398619e-8
Gw1_7_2 0 sum_h_2 in_7 vref -5.192866e-8
Gw1_8_2 0 sum_h_2 in_8 vref -1.338515e-7
Gw1_9_2 0 sum_h_2 in_9 vref -1.399648e-7
Gw1_10_2 0 sum_h_2 in_10 vref -6.874706e-8
Gw1_11_2 0 sum_h_2 in_11 vref 4.023882e-8
Gw1_12_2 0 sum_h_2 in_12 vref 1.000594e-8
Gw1_13_2 0 sum_h_2 in_13 vref 2.603938e-8
Gw1_14_2 0 sum_h_2 in_14 vref 1.065611e-7
Gw1_15_2 0 sum_h_2 in_15 vref 6.959573e-8
Gw1_16_2 0 sum_h_2 in_16 vref 1.434227e-7
Gw1_17_2 0 sum_h_2 in_17 vref -2.367925e-9
Gw1_18_2 0 sum_h_2 in_18 vref 1.497465e-7
Gw1_19_2 0 sum_h_2 in_19 vref 6.777606e-8
Gw1_20_2 0 sum_h_2 in_20 vref -1.032099e-7
Gw1_21_2 0 sum_h_2 in_21 vref 1.146442e-7
Gw1_22_2 0 sum_h_2 in_22 vref -4.022632e-8
Gw1_23_2 0 sum_h_2 in_23 vref -1.616411e-7
Gw1_24_2 0 sum_h_2 in_24 vref -1.967270e-7
Gw1_25_2 0 sum_h_2 in_25 vref -2.254533e-8
Gw1_26_2 0 sum_h_2 in_26 vref -1.317416e-7
Gw1_27_2 0 sum_h_2 in_27 vref 8.575487e-8
Gw1_28_2 0 sum_h_2 in_28 vref -9.501803e-8
Gw1_29_2 0 sum_h_2 in_29 vref -1.641831e-7
Gw1_30_2 0 sum_h_2 in_30 vref -1.933114e-7
Gw1_31_2 0 sum_h_2 in_31 vref -8.611412e-8
Gw1_32_2 0 sum_h_2 in_32 vref -9.170046e-8
Gw1_33_2 0 sum_h_2 in_33 vref 3.230062e-8
Gw1_34_2 0 sum_h_2 in_34 vref -9.491848e-8
Gw1_35_2 0 sum_h_2 in_35 vref -3.351365e-8
Gw1_36_2 0 sum_h_2 in_36 vref 1.245785e-7
Gw1_37_2 0 sum_h_2 in_37 vref 9.347497e-8
Gw1_38_2 0 sum_h_2 in_38 vref 5.720080e-8
Gw1_39_2 0 sum_h_2 in_39 vref 1.128376e-7
Gw1_40_2 0 sum_h_2 in_40 vref 1.686319e-7
Gw1_41_2 0 sum_h_2 in_41 vref -5.124636e-8
Gw1_42_2 0 sum_h_2 in_42 vref 1.105313e-7
Gw1_43_2 0 sum_h_2 in_43 vref 2.975431e-8
Gw1_44_2 0 sum_h_2 in_44 vref -6.860561e-8
Gw1_45_2 0 sum_h_2 in_45 vref -1.224929e-7
Gw1_46_2 0 sum_h_2 in_46 vref -5.251084e-8
Gw1_47_2 0 sum_h_2 in_47 vref 7.654430e-9
Gw1_48_2 0 sum_h_2 in_48 vref 9.490422e-8
Gw1_0_3 0 sum_h_3 in_0 vref 7.632711e-8
Gw1_1_3 0 sum_h_3 in_1 vref -5.284142e-8
Gw1_2_3 0 sum_h_3 in_2 vref 4.477482e-8
Gw1_3_3 0 sum_h_3 in_3 vref 6.800773e-8
Gw1_4_3 0 sum_h_3 in_4 vref -2.530054e-8
Gw1_5_3 0 sum_h_3 in_5 vref -5.905938e-8
Gw1_6_3 0 sum_h_3 in_6 vref -4.158571e-8
Gw1_7_3 0 sum_h_3 in_7 vref 3.048772e-8
Gw1_8_3 0 sum_h_3 in_8 vref 1.259835e-7
Gw1_9_3 0 sum_h_3 in_9 vref -1.078525e-7
Gw1_10_3 0 sum_h_3 in_10 vref 1.161645e-7
Gw1_11_3 0 sum_h_3 in_11 vref 3.504126e-8
Gw1_12_3 0 sum_h_3 in_12 vref -2.366339e-7
Gw1_13_3 0 sum_h_3 in_13 vref -9.710932e-8
Gw1_14_3 0 sum_h_3 in_14 vref -8.547399e-8
Gw1_15_3 0 sum_h_3 in_15 vref -4.788805e-8
Gw1_16_3 0 sum_h_3 in_16 vref -6.144598e-8
Gw1_17_3 0 sum_h_3 in_17 vref -2.404062e-8
Gw1_18_3 0 sum_h_3 in_18 vref 6.792073e-8
Gw1_19_3 0 sum_h_3 in_19 vref -1.242679e-7
Gw1_20_3 0 sum_h_3 in_20 vref -1.112294e-7
Gw1_21_3 0 sum_h_3 in_21 vref 1.163308e-9
Gw1_22_3 0 sum_h_3 in_22 vref 5.263897e-8
Gw1_23_3 0 sum_h_3 in_23 vref -9.497291e-8
Gw1_24_3 0 sum_h_3 in_24 vref 6.610235e-8
Gw1_25_3 0 sum_h_3 in_25 vref 1.202172e-7
Gw1_26_3 0 sum_h_3 in_26 vref -1.023568e-7
Gw1_27_3 0 sum_h_3 in_27 vref -4.721980e-8
Gw1_28_3 0 sum_h_3 in_28 vref 3.337543e-8
Gw1_29_3 0 sum_h_3 in_29 vref -2.350517e-7
Gw1_30_3 0 sum_h_3 in_30 vref 6.607578e-8
Gw1_31_3 0 sum_h_3 in_31 vref 5.406388e-8
Gw1_32_3 0 sum_h_3 in_32 vref -1.081444e-7
Gw1_33_3 0 sum_h_3 in_33 vref -1.717088e-7
Gw1_34_3 0 sum_h_3 in_34 vref 1.328462e-7
Gw1_35_3 0 sum_h_3 in_35 vref -1.013074e-7
Gw1_36_3 0 sum_h_3 in_36 vref 6.146597e-8
Gw1_37_3 0 sum_h_3 in_37 vref -1.252887e-7
Gw1_38_3 0 sum_h_3 in_38 vref 9.368854e-8
Gw1_39_3 0 sum_h_3 in_39 vref 1.026656e-8
Gw1_40_3 0 sum_h_3 in_40 vref -4.973059e-8
Gw1_41_3 0 sum_h_3 in_41 vref -1.739696e-8
Gw1_42_3 0 sum_h_3 in_42 vref 2.798868e-9
Gw1_43_3 0 sum_h_3 in_43 vref 9.543262e-8
Gw1_44_3 0 sum_h_3 in_44 vref 9.131321e-9
Gw1_45_3 0 sum_h_3 in_45 vref -5.150413e-10
Gw1_46_3 0 sum_h_3 in_46 vref 1.142377e-7
Gw1_47_3 0 sum_h_3 in_47 vref 3.066594e-8
Gw1_48_3 0 sum_h_3 in_48 vref -1.080884e-7
Gw1_0_4 0 sum_h_4 in_0 vref 6.636076e-8
Gw1_1_4 0 sum_h_4 in_1 vref 8.428395e-8
Gw1_2_4 0 sum_h_4 in_2 vref 1.329342e-8
Gw1_3_4 0 sum_h_4 in_3 vref -7.583450e-8
Gw1_4_4 0 sum_h_4 in_4 vref 4.941668e-8
Gw1_5_4 0 sum_h_4 in_5 vref -1.332989e-7
Gw1_6_4 0 sum_h_4 in_6 vref 5.038311e-8
Gw1_7_4 0 sum_h_4 in_7 vref 1.244160e-7
Gw1_8_4 0 sum_h_4 in_8 vref -7.055340e-8
Gw1_9_4 0 sum_h_4 in_9 vref -1.106431e-8
Gw1_10_4 0 sum_h_4 in_10 vref 2.695747e-8
Gw1_11_4 0 sum_h_4 in_11 vref -7.894779e-8
Gw1_12_4 0 sum_h_4 in_12 vref -5.927757e-8
Gw1_13_4 0 sum_h_4 in_13 vref 9.052323e-8
Gw1_14_4 0 sum_h_4 in_14 vref 1.084303e-7
Gw1_15_4 0 sum_h_4 in_15 vref 8.809681e-8
Gw1_16_4 0 sum_h_4 in_16 vref -4.599772e-8
Gw1_17_4 0 sum_h_4 in_17 vref 3.226360e-8
Gw1_18_4 0 sum_h_4 in_18 vref -5.582162e-9
Gw1_19_4 0 sum_h_4 in_19 vref 1.499859e-7
Gw1_20_4 0 sum_h_4 in_20 vref -1.305562e-7
Gw1_21_4 0 sum_h_4 in_21 vref 7.490291e-8
Gw1_22_4 0 sum_h_4 in_22 vref -1.780839e-8
Gw1_23_4 0 sum_h_4 in_23 vref 1.622757e-7
Gw1_24_4 0 sum_h_4 in_24 vref -1.016179e-7
Gw1_25_4 0 sum_h_4 in_25 vref 1.253678e-7
Gw1_26_4 0 sum_h_4 in_26 vref 6.367651e-8
Gw1_27_4 0 sum_h_4 in_27 vref -2.986129e-8
Gw1_28_4 0 sum_h_4 in_28 vref -1.207016e-7
Gw1_29_4 0 sum_h_4 in_29 vref -3.556310e-8
Gw1_30_4 0 sum_h_4 in_30 vref -8.214043e-8
Gw1_31_4 0 sum_h_4 in_31 vref -2.004890e-7
Gw1_32_4 0 sum_h_4 in_32 vref 4.082918e-8
Gw1_33_4 0 sum_h_4 in_33 vref -9.432952e-8
Gw1_34_4 0 sum_h_4 in_34 vref 7.251674e-8
Gw1_35_4 0 sum_h_4 in_35 vref 4.064731e-8
Gw1_36_4 0 sum_h_4 in_36 vref -1.118802e-7
Gw1_37_4 0 sum_h_4 in_37 vref -1.044974e-7
Gw1_38_4 0 sum_h_4 in_38 vref -1.838316e-7
Gw1_39_4 0 sum_h_4 in_39 vref 1.974851e-7
Gw1_40_4 0 sum_h_4 in_40 vref -1.656533e-7
Gw1_41_4 0 sum_h_4 in_41 vref -4.146794e-8
Gw1_42_4 0 sum_h_4 in_42 vref -1.298245e-7
Gw1_43_4 0 sum_h_4 in_43 vref 8.236746e-9
Gw1_44_4 0 sum_h_4 in_44 vref -6.398761e-9
Gw1_45_4 0 sum_h_4 in_45 vref -1.873701e-7
Gw1_46_4 0 sum_h_4 in_46 vref 2.381169e-7
Gw1_47_4 0 sum_h_4 in_47 vref -5.983912e-8
Gw1_48_4 0 sum_h_4 in_48 vref 8.699799e-8
Gw1_0_5 0 sum_h_5 in_0 vref 5.484697e-8
Gw1_1_5 0 sum_h_5 in_1 vref -4.420514e-8
Gw1_2_5 0 sum_h_5 in_2 vref 1.255260e-7
Gw1_3_5 0 sum_h_5 in_3 vref 6.369943e-8
Gw1_4_5 0 sum_h_5 in_4 vref 9.663344e-9
Gw1_5_5 0 sum_h_5 in_5 vref 2.247321e-8
Gw1_6_5 0 sum_h_5 in_6 vref 1.230502e-7
Gw1_7_5 0 sum_h_5 in_7 vref -1.330402e-8
Gw1_8_5 0 sum_h_5 in_8 vref 9.881348e-8
Gw1_9_5 0 sum_h_5 in_9 vref 2.150563e-8
Gw1_10_5 0 sum_h_5 in_10 vref -6.493647e-8
Gw1_11_5 0 sum_h_5 in_11 vref -1.061485e-8
Gw1_12_5 0 sum_h_5 in_12 vref -3.931246e-8
Gw1_13_5 0 sum_h_5 in_13 vref -1.473143e-8
Gw1_14_5 0 sum_h_5 in_14 vref 9.977940e-8
Gw1_15_5 0 sum_h_5 in_15 vref -8.042938e-8
Gw1_16_5 0 sum_h_5 in_16 vref -9.035234e-8
Gw1_17_5 0 sum_h_5 in_17 vref -1.684190e-8
Gw1_18_5 0 sum_h_5 in_18 vref 1.444810e-7
Gw1_19_5 0 sum_h_5 in_19 vref 1.307999e-7
Gw1_20_5 0 sum_h_5 in_20 vref -7.001368e-8
Gw1_21_5 0 sum_h_5 in_21 vref -8.515743e-8
Gw1_22_5 0 sum_h_5 in_22 vref -2.273632e-9
Gw1_23_5 0 sum_h_5 in_23 vref -8.984144e-8
Gw1_24_5 0 sum_h_5 in_24 vref 4.034971e-8
Gw1_25_5 0 sum_h_5 in_25 vref -1.171312e-7
Gw1_26_5 0 sum_h_5 in_26 vref -3.046048e-8
Gw1_27_5 0 sum_h_5 in_27 vref -3.256186e-8
Gw1_28_5 0 sum_h_5 in_28 vref -1.895830e-8
Gw1_29_5 0 sum_h_5 in_29 vref -1.111259e-7
Gw1_30_5 0 sum_h_5 in_30 vref -7.875047e-8
Gw1_31_5 0 sum_h_5 in_31 vref 4.602927e-8
Gw1_32_5 0 sum_h_5 in_32 vref 1.257613e-8
Gw1_33_5 0 sum_h_5 in_33 vref 4.872673e-8
Gw1_34_5 0 sum_h_5 in_34 vref 1.296817e-7
Gw1_35_5 0 sum_h_5 in_35 vref -1.801691e-8
Gw1_36_5 0 sum_h_5 in_36 vref 1.630005e-7
Gw1_37_5 0 sum_h_5 in_37 vref -7.548228e-8
Gw1_38_5 0 sum_h_5 in_38 vref 1.075479e-8
Gw1_39_5 0 sum_h_5 in_39 vref -1.356289e-7
Gw1_40_5 0 sum_h_5 in_40 vref 6.284390e-8
Gw1_41_5 0 sum_h_5 in_41 vref -3.299558e-8
Gw1_42_5 0 sum_h_5 in_42 vref 1.924972e-8
Gw1_43_5 0 sum_h_5 in_43 vref 5.337583e-9
Gw1_44_5 0 sum_h_5 in_44 vref -7.983003e-8
Gw1_45_5 0 sum_h_5 in_45 vref -5.290850e-8
Gw1_46_5 0 sum_h_5 in_46 vref -7.692633e-8
Gw1_47_5 0 sum_h_5 in_47 vref -6.137899e-8
Gw1_48_5 0 sum_h_5 in_48 vref 1.012467e-7
Gw1_0_6 0 sum_h_6 in_0 vref -1.021380e-7
Gw1_1_6 0 sum_h_6 in_1 vref 1.030055e-7
Gw1_2_6 0 sum_h_6 in_2 vref -3.651687e-8
Gw1_3_6 0 sum_h_6 in_3 vref -9.433816e-8
Gw1_4_6 0 sum_h_6 in_4 vref 6.767900e-8
Gw1_5_6 0 sum_h_6 in_5 vref 4.817113e-8
Gw1_6_6 0 sum_h_6 in_6 vref -2.970474e-8
Gw1_7_6 0 sum_h_6 in_7 vref -1.183334e-7
Gw1_8_6 0 sum_h_6 in_8 vref 3.580884e-8
Gw1_9_6 0 sum_h_6 in_9 vref 4.313386e-8
Gw1_10_6 0 sum_h_6 in_10 vref 1.001970e-7
Gw1_11_6 0 sum_h_6 in_11 vref 2.206884e-8
Gw1_12_6 0 sum_h_6 in_12 vref 1.552790e-8
Gw1_13_6 0 sum_h_6 in_13 vref -1.003689e-7
Gw1_14_6 0 sum_h_6 in_14 vref -5.063088e-8
Gw1_15_6 0 sum_h_6 in_15 vref 2.471758e-8
Gw1_16_6 0 sum_h_6 in_16 vref 9.468489e-8
Gw1_17_6 0 sum_h_6 in_17 vref 1.657710e-7
Gw1_18_6 0 sum_h_6 in_18 vref -2.261982e-8
Gw1_19_6 0 sum_h_6 in_19 vref 7.386922e-8
Gw1_20_6 0 sum_h_6 in_20 vref 5.949265e-8
Gw1_21_6 0 sum_h_6 in_21 vref 4.317645e-8
Gw1_22_6 0 sum_h_6 in_22 vref -9.478834e-8
Gw1_23_6 0 sum_h_6 in_23 vref -4.349058e-8
Gw1_24_6 0 sum_h_6 in_24 vref 9.602876e-8
Gw1_25_6 0 sum_h_6 in_25 vref 1.525051e-7
Gw1_26_6 0 sum_h_6 in_26 vref 2.998807e-8
Gw1_27_6 0 sum_h_6 in_27 vref -1.575216e-8
Gw1_28_6 0 sum_h_6 in_28 vref -7.672578e-9
Gw1_29_6 0 sum_h_6 in_29 vref -4.634946e-9
Gw1_30_6 0 sum_h_6 in_30 vref -8.415861e-8
Gw1_31_6 0 sum_h_6 in_31 vref 6.476003e-8
Gw1_32_6 0 sum_h_6 in_32 vref 6.381047e-8
Gw1_33_6 0 sum_h_6 in_33 vref -4.867953e-8
Gw1_34_6 0 sum_h_6 in_34 vref -5.449896e-8
Gw1_35_6 0 sum_h_6 in_35 vref -3.638865e-8
Gw1_36_6 0 sum_h_6 in_36 vref -7.272245e-9
Gw1_37_6 0 sum_h_6 in_37 vref 9.779742e-8
Gw1_38_6 0 sum_h_6 in_38 vref 8.047913e-8
Gw1_39_6 0 sum_h_6 in_39 vref -1.176559e-7
Gw1_40_6 0 sum_h_6 in_40 vref -1.017835e-8
Gw1_41_6 0 sum_h_6 in_41 vref -1.650069e-9
Gw1_42_6 0 sum_h_6 in_42 vref -5.697357e-8
Gw1_43_6 0 sum_h_6 in_43 vref 1.197576e-8
Gw1_44_6 0 sum_h_6 in_44 vref 1.359077e-7
Gw1_45_6 0 sum_h_6 in_45 vref 1.422817e-7
Gw1_46_6 0 sum_h_6 in_46 vref 2.286238e-7
Gw1_47_6 0 sum_h_6 in_47 vref -2.651721e-8
Gw1_48_6 0 sum_h_6 in_48 vref -4.400425e-8
Gw1_0_7 0 sum_h_7 in_0 vref 4.153351e-8
Gw1_1_7 0 sum_h_7 in_1 vref 1.444643e-7
Gw1_2_7 0 sum_h_7 in_2 vref -7.908660e-8
Gw1_3_7 0 sum_h_7 in_3 vref 8.181979e-8
Gw1_4_7 0 sum_h_7 in_4 vref -6.448819e-8
Gw1_5_7 0 sum_h_7 in_5 vref -8.617494e-8
Gw1_6_7 0 sum_h_7 in_6 vref 3.848795e-8
Gw1_7_7 0 sum_h_7 in_7 vref -7.200305e-8
Gw1_8_7 0 sum_h_7 in_8 vref 4.544654e-8
Gw1_9_7 0 sum_h_7 in_9 vref 9.004850e-8
Gw1_10_7 0 sum_h_7 in_10 vref -4.731919e-8
Gw1_11_7 0 sum_h_7 in_11 vref 2.692348e-8
Gw1_12_7 0 sum_h_7 in_12 vref 9.578887e-8
Gw1_13_7 0 sum_h_7 in_13 vref 7.771879e-9
Gw1_14_7 0 sum_h_7 in_14 vref 7.683693e-8
Gw1_15_7 0 sum_h_7 in_15 vref 2.080763e-8
Gw1_16_7 0 sum_h_7 in_16 vref -3.139121e-8
Gw1_17_7 0 sum_h_7 in_17 vref -5.090600e-8
Gw1_18_7 0 sum_h_7 in_18 vref 3.581631e-9
Gw1_19_7 0 sum_h_7 in_19 vref 1.344342e-7
Gw1_20_7 0 sum_h_7 in_20 vref -3.261026e-8
Gw1_21_7 0 sum_h_7 in_21 vref -6.878200e-8
Gw1_22_7 0 sum_h_7 in_22 vref 4.888602e-8
Gw1_23_7 0 sum_h_7 in_23 vref -9.738434e-9
Gw1_24_7 0 sum_h_7 in_24 vref -1.980973e-7
Gw1_25_7 0 sum_h_7 in_25 vref 1.520847e-7
Gw1_26_7 0 sum_h_7 in_26 vref -7.242907e-8
Gw1_27_7 0 sum_h_7 in_27 vref 1.263248e-8
Gw1_28_7 0 sum_h_7 in_28 vref 6.536203e-8
Gw1_29_7 0 sum_h_7 in_29 vref -2.077227e-8
Gw1_30_7 0 sum_h_7 in_30 vref -5.728639e-8
Gw1_31_7 0 sum_h_7 in_31 vref 1.180123e-8
Gw1_32_7 0 sum_h_7 in_32 vref -7.124111e-8
Gw1_33_7 0 sum_h_7 in_33 vref -1.160202e-7
Gw1_34_7 0 sum_h_7 in_34 vref 1.969681e-8
Gw1_35_7 0 sum_h_7 in_35 vref 9.386608e-8
Gw1_36_7 0 sum_h_7 in_36 vref -2.318799e-8
Gw1_37_7 0 sum_h_7 in_37 vref 1.497325e-7
Gw1_38_7 0 sum_h_7 in_38 vref -1.285369e-7
Gw1_39_7 0 sum_h_7 in_39 vref -1.941318e-7
Gw1_40_7 0 sum_h_7 in_40 vref -2.684139e-8
Gw1_41_7 0 sum_h_7 in_41 vref -1.165018e-7
Gw1_42_7 0 sum_h_7 in_42 vref -4.407434e-8
Gw1_43_7 0 sum_h_7 in_43 vref 1.682861e-7
Gw1_44_7 0 sum_h_7 in_44 vref 2.167494e-7
Gw1_45_7 0 sum_h_7 in_45 vref -1.221587e-7
Gw1_46_7 0 sum_h_7 in_46 vref -1.624971e-7
Gw1_47_7 0 sum_h_7 in_47 vref 4.415449e-8
Gw1_48_7 0 sum_h_7 in_48 vref -7.052721e-8
Gw1_0_8 0 sum_h_8 in_0 vref -7.475177e-8
Gw1_1_8 0 sum_h_8 in_1 vref 6.947358e-8
Gw1_2_8 0 sum_h_8 in_2 vref 6.031550e-8
Gw1_3_8 0 sum_h_8 in_3 vref 1.379486e-8
Gw1_4_8 0 sum_h_8 in_4 vref -2.701899e-8
Gw1_5_8 0 sum_h_8 in_5 vref -3.023074e-8
Gw1_6_8 0 sum_h_8 in_6 vref 7.357286e-8
Gw1_7_8 0 sum_h_8 in_7 vref 1.402272e-7
Gw1_8_8 0 sum_h_8 in_8 vref 3.487547e-8
Gw1_9_8 0 sum_h_8 in_9 vref 6.991272e-8
Gw1_10_8 0 sum_h_8 in_10 vref -1.039984e-7
Gw1_11_8 0 sum_h_8 in_11 vref 6.119689e-8
Gw1_12_8 0 sum_h_8 in_12 vref 3.971908e-8
Gw1_13_8 0 sum_h_8 in_13 vref 1.452752e-7
Gw1_14_8 0 sum_h_8 in_14 vref -9.934254e-8
Gw1_15_8 0 sum_h_8 in_15 vref 2.915331e-8
Gw1_16_8 0 sum_h_8 in_16 vref 1.234769e-8
Gw1_17_8 0 sum_h_8 in_17 vref -9.709867e-8
Gw1_18_8 0 sum_h_8 in_18 vref -7.768402e-9
Gw1_19_8 0 sum_h_8 in_19 vref -1.062517e-7
Gw1_20_8 0 sum_h_8 in_20 vref 7.744653e-8
Gw1_21_8 0 sum_h_8 in_21 vref 1.390570e-8
Gw1_22_8 0 sum_h_8 in_22 vref -7.299392e-8
Gw1_23_8 0 sum_h_8 in_23 vref 1.703324e-7
Gw1_24_8 0 sum_h_8 in_24 vref 1.464288e-7
Gw1_25_8 0 sum_h_8 in_25 vref -1.063956e-7
Gw1_26_8 0 sum_h_8 in_26 vref -6.838903e-8
Gw1_27_8 0 sum_h_8 in_27 vref -7.109175e-10
Gw1_28_8 0 sum_h_8 in_28 vref 3.499729e-8
Gw1_29_8 0 sum_h_8 in_29 vref -3.064846e-7
Gw1_30_8 0 sum_h_8 in_30 vref -2.667761e-7
Gw1_31_8 0 sum_h_8 in_31 vref -1.808726e-7
Gw1_32_8 0 sum_h_8 in_32 vref 1.474783e-8
Gw1_33_8 0 sum_h_8 in_33 vref 6.707648e-8
Gw1_34_8 0 sum_h_8 in_34 vref -7.370453e-8
Gw1_35_8 0 sum_h_8 in_35 vref -6.566601e-8
Gw1_36_8 0 sum_h_8 in_36 vref 1.583224e-7
Gw1_37_8 0 sum_h_8 in_37 vref 7.108088e-8
Gw1_38_8 0 sum_h_8 in_38 vref 1.028594e-7
Gw1_39_8 0 sum_h_8 in_39 vref 7.207670e-8
Gw1_40_8 0 sum_h_8 in_40 vref 5.571664e-8
Gw1_41_8 0 sum_h_8 in_41 vref -3.441388e-8
Gw1_42_8 0 sum_h_8 in_42 vref -1.093608e-7
Gw1_43_8 0 sum_h_8 in_43 vref -7.498343e-8
Gw1_44_8 0 sum_h_8 in_44 vref 1.104072e-7
Gw1_45_8 0 sum_h_8 in_45 vref 8.405411e-8
Gw1_46_8 0 sum_h_8 in_46 vref 7.730144e-8
Gw1_47_8 0 sum_h_8 in_47 vref -4.951060e-8
Gw1_48_8 0 sum_h_8 in_48 vref -1.015694e-7
Gw1_0_9 0 sum_h_9 in_0 vref 1.288962e-7
Gw1_1_9 0 sum_h_9 in_1 vref -1.034683e-8
Gw1_2_9 0 sum_h_9 in_2 vref 1.095356e-7
Gw1_3_9 0 sum_h_9 in_3 vref 3.696567e-8
Gw1_4_9 0 sum_h_9 in_4 vref -1.216578e-8
Gw1_5_9 0 sum_h_9 in_5 vref 1.927105e-8
Gw1_6_9 0 sum_h_9 in_6 vref -1.164161e-7
Gw1_7_9 0 sum_h_9 in_7 vref 4.834512e-8
Gw1_8_9 0 sum_h_9 in_8 vref -1.492436e-7
Gw1_9_9 0 sum_h_9 in_9 vref -1.112068e-7
Gw1_10_9 0 sum_h_9 in_10 vref -1.114334e-7
Gw1_11_9 0 sum_h_9 in_11 vref -1.305996e-7
Gw1_12_9 0 sum_h_9 in_12 vref -1.034981e-7
Gw1_13_9 0 sum_h_9 in_13 vref 4.607204e-9
Gw1_14_9 0 sum_h_9 in_14 vref 7.091929e-8
Gw1_15_9 0 sum_h_9 in_15 vref 1.494483e-7
Gw1_16_9 0 sum_h_9 in_16 vref 2.158617e-7
Gw1_17_9 0 sum_h_9 in_17 vref 1.376786e-7
Gw1_18_9 0 sum_h_9 in_18 vref -4.366538e-8
Gw1_19_9 0 sum_h_9 in_19 vref -1.282935e-7
Gw1_20_9 0 sum_h_9 in_20 vref -1.051497e-7
Gw1_21_9 0 sum_h_9 in_21 vref 1.019194e-7
Gw1_22_9 0 sum_h_9 in_22 vref 1.306867e-8
Gw1_23_9 0 sum_h_9 in_23 vref -4.302168e-8
Gw1_24_9 0 sum_h_9 in_24 vref 2.227678e-8
Gw1_25_9 0 sum_h_9 in_25 vref -4.280780e-8
Gw1_26_9 0 sum_h_9 in_26 vref 8.107853e-8
Gw1_27_9 0 sum_h_9 in_27 vref -6.737930e-8
Gw1_28_9 0 sum_h_9 in_28 vref -1.082967e-7
Gw1_29_9 0 sum_h_9 in_29 vref -1.797321e-9
Gw1_30_9 0 sum_h_9 in_30 vref 1.099181e-7
Gw1_31_9 0 sum_h_9 in_31 vref -8.006057e-8
Gw1_32_9 0 sum_h_9 in_32 vref -6.951284e-8
Gw1_33_9 0 sum_h_9 in_33 vref 2.647766e-8
Gw1_34_9 0 sum_h_9 in_34 vref -1.117205e-7
Gw1_35_9 0 sum_h_9 in_35 vref -1.135010e-7
Gw1_36_9 0 sum_h_9 in_36 vref 1.698495e-8
Gw1_37_9 0 sum_h_9 in_37 vref -3.819320e-7
Gw1_38_9 0 sum_h_9 in_38 vref -1.586573e-7
Gw1_39_9 0 sum_h_9 in_39 vref -1.212721e-7
Gw1_40_9 0 sum_h_9 in_40 vref -1.217876e-7
Gw1_41_9 0 sum_h_9 in_41 vref 1.526085e-8
Gw1_42_9 0 sum_h_9 in_42 vref -9.977673e-8
Gw1_43_9 0 sum_h_9 in_43 vref -3.737953e-8
Gw1_44_9 0 sum_h_9 in_44 vref -5.064269e-8
Gw1_45_9 0 sum_h_9 in_45 vref 2.621538e-7
Gw1_46_9 0 sum_h_9 in_46 vref 5.191599e-8
Gw1_47_9 0 sum_h_9 in_47 vref -2.046630e-8
Gw1_48_9 0 sum_h_9 in_48 vref 7.121589e-8
Gw1_0_10 0 sum_h_10 in_0 vref 2.382281e-8
Gw1_1_10 0 sum_h_10 in_1 vref 6.292403e-8
Gw1_2_10 0 sum_h_10 in_2 vref 8.752716e-8
Gw1_3_10 0 sum_h_10 in_3 vref -7.368041e-8
Gw1_4_10 0 sum_h_10 in_4 vref 1.042837e-7
Gw1_5_10 0 sum_h_10 in_5 vref 1.499092e-7
Gw1_6_10 0 sum_h_10 in_6 vref -5.276209e-8
Gw1_7_10 0 sum_h_10 in_7 vref 9.085665e-8
Gw1_8_10 0 sum_h_10 in_8 vref -1.718732e-7
Gw1_9_10 0 sum_h_10 in_9 vref -8.210117e-8
Gw1_10_10 0 sum_h_10 in_10 vref 1.299628e-7
Gw1_11_10 0 sum_h_10 in_11 vref 8.231909e-8
Gw1_12_10 0 sum_h_10 in_12 vref -1.282252e-7
Gw1_13_10 0 sum_h_10 in_13 vref 1.483053e-7
Gw1_14_10 0 sum_h_10 in_14 vref 7.042772e-8
Gw1_15_10 0 sum_h_10 in_15 vref -1.313919e-7
Gw1_16_10 0 sum_h_10 in_16 vref 7.135387e-8
Gw1_17_10 0 sum_h_10 in_17 vref 4.042146e-8
Gw1_18_10 0 sum_h_10 in_18 vref -5.126828e-8
Gw1_19_10 0 sum_h_10 in_19 vref -9.960350e-8
Gw1_20_10 0 sum_h_10 in_20 vref -8.034264e-8
Gw1_21_10 0 sum_h_10 in_21 vref 8.597463e-8
Gw1_22_10 0 sum_h_10 in_22 vref -6.301588e-8
Gw1_23_10 0 sum_h_10 in_23 vref -1.619442e-8
Gw1_24_10 0 sum_h_10 in_24 vref 9.613179e-8
Gw1_25_10 0 sum_h_10 in_25 vref 8.563584e-9
Gw1_26_10 0 sum_h_10 in_26 vref -6.115254e-8
Gw1_27_10 0 sum_h_10 in_27 vref 5.971917e-8
Gw1_28_10 0 sum_h_10 in_28 vref -5.138996e-8
Gw1_29_10 0 sum_h_10 in_29 vref -8.780514e-8
Gw1_30_10 0 sum_h_10 in_30 vref -1.550341e-7
Gw1_31_10 0 sum_h_10 in_31 vref -1.140360e-7
Gw1_32_10 0 sum_h_10 in_32 vref -1.106649e-7
Gw1_33_10 0 sum_h_10 in_33 vref -8.019926e-8
Gw1_34_10 0 sum_h_10 in_34 vref -1.385015e-7
Gw1_35_10 0 sum_h_10 in_35 vref 1.079821e-7
Gw1_36_10 0 sum_h_10 in_36 vref 1.927148e-7
Gw1_37_10 0 sum_h_10 in_37 vref 1.463198e-8
Gw1_38_10 0 sum_h_10 in_38 vref 7.261737e-8
Gw1_39_10 0 sum_h_10 in_39 vref 6.007272e-8
Gw1_40_10 0 sum_h_10 in_40 vref -6.566444e-8
Gw1_41_10 0 sum_h_10 in_41 vref -4.467729e-9
Gw1_42_10 0 sum_h_10 in_42 vref -1.231251e-7
Gw1_43_10 0 sum_h_10 in_43 vref 3.007951e-8
Gw1_44_10 0 sum_h_10 in_44 vref 1.181607e-8
Gw1_45_10 0 sum_h_10 in_45 vref -9.415343e-8
Gw1_46_10 0 sum_h_10 in_46 vref 8.457927e-8
Gw1_47_10 0 sum_h_10 in_47 vref 3.890199e-8
Gw1_48_10 0 sum_h_10 in_48 vref 1.392940e-7
Gw1_0_11 0 sum_h_11 in_0 vref 6.349122e-8
Gw1_1_11 0 sum_h_11 in_1 vref 1.803600e-8
Gw1_2_11 0 sum_h_11 in_2 vref 4.521163e-8
Gw1_3_11 0 sum_h_11 in_3 vref 8.524005e-8
Gw1_4_11 0 sum_h_11 in_4 vref -5.341471e-8
Gw1_5_11 0 sum_h_11 in_5 vref -6.509834e-8
Gw1_6_11 0 sum_h_11 in_6 vref -1.261325e-7
Gw1_7_11 0 sum_h_11 in_7 vref -1.555824e-7
Gw1_8_11 0 sum_h_11 in_8 vref 5.745732e-9
Gw1_9_11 0 sum_h_11 in_9 vref 2.044772e-8
Gw1_10_11 0 sum_h_11 in_10 vref 7.515250e-8
Gw1_11_11 0 sum_h_11 in_11 vref 1.074654e-7
Gw1_12_11 0 sum_h_11 in_12 vref -3.033151e-8
Gw1_13_11 0 sum_h_11 in_13 vref 8.434363e-8
Gw1_14_11 0 sum_h_11 in_14 vref 8.028081e-8
Gw1_15_11 0 sum_h_11 in_15 vref -7.799540e-8
Gw1_16_11 0 sum_h_11 in_16 vref 1.059954e-7
Gw1_17_11 0 sum_h_11 in_17 vref -5.501467e-8
Gw1_18_11 0 sum_h_11 in_18 vref -1.615747e-7
Gw1_19_11 0 sum_h_11 in_19 vref -2.180592e-7
Gw1_20_11 0 sum_h_11 in_20 vref -2.730127e-8
Gw1_21_11 0 sum_h_11 in_21 vref 7.764658e-8
Gw1_22_11 0 sum_h_11 in_22 vref 2.750125e-8
Gw1_23_11 0 sum_h_11 in_23 vref -6.598329e-8
Gw1_24_11 0 sum_h_11 in_24 vref -9.960995e-8
Gw1_25_11 0 sum_h_11 in_25 vref 1.495417e-7
Gw1_26_11 0 sum_h_11 in_26 vref 1.468064e-7
Gw1_27_11 0 sum_h_11 in_27 vref 7.238742e-8
Gw1_28_11 0 sum_h_11 in_28 vref -4.609902e-8
Gw1_29_11 0 sum_h_11 in_29 vref 9.814507e-8
Gw1_30_11 0 sum_h_11 in_30 vref 1.437212e-8
Gw1_31_11 0 sum_h_11 in_31 vref -1.779098e-7
Gw1_32_11 0 sum_h_11 in_32 vref -1.424996e-7
Gw1_33_11 0 sum_h_11 in_33 vref 2.180752e-7
Gw1_34_11 0 sum_h_11 in_34 vref -6.395740e-8
Gw1_35_11 0 sum_h_11 in_35 vref -7.256460e-8
Gw1_36_11 0 sum_h_11 in_36 vref -5.259883e-8
Gw1_37_11 0 sum_h_11 in_37 vref -2.543618e-8
Gw1_38_11 0 sum_h_11 in_38 vref 3.370244e-8
Gw1_39_11 0 sum_h_11 in_39 vref 1.030837e-7
Gw1_40_11 0 sum_h_11 in_40 vref 9.247677e-8
Gw1_41_11 0 sum_h_11 in_41 vref 3.764222e-8
Gw1_42_11 0 sum_h_11 in_42 vref -1.509394e-7
Gw1_43_11 0 sum_h_11 in_43 vref 7.725941e-8
Gw1_44_11 0 sum_h_11 in_44 vref -3.476597e-8
Gw1_45_11 0 sum_h_11 in_45 vref -1.439296e-7
Gw1_46_11 0 sum_h_11 in_46 vref 9.749729e-8
Gw1_47_11 0 sum_h_11 in_47 vref 8.783523e-8
Gw1_48_11 0 sum_h_11 in_48 vref -7.697422e-8
Gw1_0_12 0 sum_h_12 in_0 vref 5.271342e-8
Gw1_1_12 0 sum_h_12 in_1 vref 1.402003e-7
Gw1_2_12 0 sum_h_12 in_2 vref 7.725566e-8
Gw1_3_12 0 sum_h_12 in_3 vref -9.408883e-8
Gw1_4_12 0 sum_h_12 in_4 vref -1.180796e-7
Gw1_5_12 0 sum_h_12 in_5 vref -3.832681e-8
Gw1_6_12 0 sum_h_12 in_6 vref 2.507005e-8
Gw1_7_12 0 sum_h_12 in_7 vref -5.321735e-8
Gw1_8_12 0 sum_h_12 in_8 vref -1.910247e-9
Gw1_9_12 0 sum_h_12 in_9 vref 5.907711e-8
Gw1_10_12 0 sum_h_12 in_10 vref -1.566252e-8
Gw1_11_12 0 sum_h_12 in_11 vref -9.988567e-8
Gw1_12_12 0 sum_h_12 in_12 vref -1.273850e-7
Gw1_13_12 0 sum_h_12 in_13 vref -3.981778e-8
Gw1_14_12 0 sum_h_12 in_14 vref 3.191589e-8
Gw1_15_12 0 sum_h_12 in_15 vref -7.522477e-8
Gw1_16_12 0 sum_h_12 in_16 vref -5.801374e-8
Gw1_17_12 0 sum_h_12 in_17 vref 6.530215e-8
Gw1_18_12 0 sum_h_12 in_18 vref 6.242342e-8
Gw1_19_12 0 sum_h_12 in_19 vref -2.461498e-7
Gw1_20_12 0 sum_h_12 in_20 vref -9.787962e-8
Gw1_21_12 0 sum_h_12 in_21 vref -2.466300e-8
Gw1_22_12 0 sum_h_12 in_22 vref -1.926787e-8
Gw1_23_12 0 sum_h_12 in_23 vref -8.376767e-8
Gw1_24_12 0 sum_h_12 in_24 vref 1.746330e-8
Gw1_25_12 0 sum_h_12 in_25 vref 3.778190e-8
Gw1_26_12 0 sum_h_12 in_26 vref -2.998965e-8
Gw1_27_12 0 sum_h_12 in_27 vref 1.003313e-7
Gw1_28_12 0 sum_h_12 in_28 vref 1.383298e-7
Gw1_29_12 0 sum_h_12 in_29 vref 3.167463e-8
Gw1_30_12 0 sum_h_12 in_30 vref -1.774426e-7
Gw1_31_12 0 sum_h_12 in_31 vref 1.706246e-7
Gw1_32_12 0 sum_h_12 in_32 vref 5.775540e-8
Gw1_33_12 0 sum_h_12 in_33 vref 1.894296e-8
Gw1_34_12 0 sum_h_12 in_34 vref -8.759259e-8
Gw1_35_12 0 sum_h_12 in_35 vref 2.181748e-8
Gw1_36_12 0 sum_h_12 in_36 vref -1.636763e-7
Gw1_37_12 0 sum_h_12 in_37 vref -1.193894e-7
Gw1_38_12 0 sum_h_12 in_38 vref 1.493694e-7
Gw1_39_12 0 sum_h_12 in_39 vref 2.618532e-8
Gw1_40_12 0 sum_h_12 in_40 vref 5.619742e-8
Gw1_41_12 0 sum_h_12 in_41 vref 6.895880e-8
Gw1_42_12 0 sum_h_12 in_42 vref 1.013193e-8
Gw1_43_12 0 sum_h_12 in_43 vref 7.892763e-8
Gw1_44_12 0 sum_h_12 in_44 vref 8.543283e-9
Gw1_45_12 0 sum_h_12 in_45 vref 6.990121e-8
Gw1_46_12 0 sum_h_12 in_46 vref -3.888278e-9
Gw1_47_12 0 sum_h_12 in_47 vref -8.922113e-8
Gw1_48_12 0 sum_h_12 in_48 vref 1.067224e-7
Gw1_0_13 0 sum_h_13 in_0 vref -1.169206e-7
Gw1_1_13 0 sum_h_13 in_1 vref 2.956443e-8
Gw1_2_13 0 sum_h_13 in_2 vref -1.573486e-7
Gw1_3_13 0 sum_h_13 in_3 vref 1.211709e-7
Gw1_4_13 0 sum_h_13 in_4 vref -2.722209e-8
Gw1_5_13 0 sum_h_13 in_5 vref 4.442992e-9
Gw1_6_13 0 sum_h_13 in_6 vref 6.436230e-8
Gw1_7_13 0 sum_h_13 in_7 vref -1.251884e-8
Gw1_8_13 0 sum_h_13 in_8 vref -1.462962e-7
Gw1_9_13 0 sum_h_13 in_9 vref -1.749821e-7
Gw1_10_13 0 sum_h_13 in_10 vref -8.422174e-8
Gw1_11_13 0 sum_h_13 in_11 vref -7.874013e-9
Gw1_12_13 0 sum_h_13 in_12 vref -6.899469e-8
Gw1_13_13 0 sum_h_13 in_13 vref -1.708393e-7
Gw1_14_13 0 sum_h_13 in_14 vref -7.690864e-8
Gw1_15_13 0 sum_h_13 in_15 vref 9.888910e-9
Gw1_16_13 0 sum_h_13 in_16 vref 1.642520e-8
Gw1_17_13 0 sum_h_13 in_17 vref 4.320437e-8
Gw1_18_13 0 sum_h_13 in_18 vref 9.258307e-8
Gw1_19_13 0 sum_h_13 in_19 vref 1.388464e-7
Gw1_20_13 0 sum_h_13 in_20 vref -4.413634e-8
Gw1_21_13 0 sum_h_13 in_21 vref 1.411477e-7
Gw1_22_13 0 sum_h_13 in_22 vref 3.144411e-8
Gw1_23_13 0 sum_h_13 in_23 vref 3.332605e-9
Gw1_24_13 0 sum_h_13 in_24 vref -9.294683e-8
Gw1_25_13 0 sum_h_13 in_25 vref -4.933704e-8
Gw1_26_13 0 sum_h_13 in_26 vref 1.312646e-7
Gw1_27_13 0 sum_h_13 in_27 vref -1.265302e-7
Gw1_28_13 0 sum_h_13 in_28 vref -6.005271e-8
Gw1_29_13 0 sum_h_13 in_29 vref 7.268580e-8
Gw1_30_13 0 sum_h_13 in_30 vref 3.782366e-8
Gw1_31_13 0 sum_h_13 in_31 vref -7.058566e-8
Gw1_32_13 0 sum_h_13 in_32 vref 7.972895e-8
Gw1_33_13 0 sum_h_13 in_33 vref -3.897695e-8
Gw1_34_13 0 sum_h_13 in_34 vref 7.850749e-8
Gw1_35_13 0 sum_h_13 in_35 vref 7.850285e-8
Gw1_36_13 0 sum_h_13 in_36 vref -6.032907e-8
Gw1_37_13 0 sum_h_13 in_37 vref 4.734163e-8
Gw1_38_13 0 sum_h_13 in_38 vref 1.357838e-7
Gw1_39_13 0 sum_h_13 in_39 vref -1.009197e-8
Gw1_40_13 0 sum_h_13 in_40 vref 9.382564e-8
Gw1_41_13 0 sum_h_13 in_41 vref 5.294444e-8
Gw1_42_13 0 sum_h_13 in_42 vref -2.860604e-8
Gw1_43_13 0 sum_h_13 in_43 vref 1.353677e-8
Gw1_44_13 0 sum_h_13 in_44 vref 5.619768e-8
Gw1_45_13 0 sum_h_13 in_45 vref 1.078050e-7
Gw1_46_13 0 sum_h_13 in_46 vref -2.024322e-8
Gw1_47_13 0 sum_h_13 in_47 vref 1.385826e-7
Gw1_48_13 0 sum_h_13 in_48 vref -1.022426e-8
Gw1_0_14 0 sum_h_14 in_0 vref -2.679455e-8
Gw1_1_14 0 sum_h_14 in_1 vref -5.199530e-8
Gw1_2_14 0 sum_h_14 in_2 vref 1.539883e-7
Gw1_3_14 0 sum_h_14 in_3 vref 1.008354e-7
Gw1_4_14 0 sum_h_14 in_4 vref -1.067108e-7
Gw1_5_14 0 sum_h_14 in_5 vref -5.379501e-8
Gw1_6_14 0 sum_h_14 in_6 vref 1.080712e-7
Gw1_7_14 0 sum_h_14 in_7 vref -8.120070e-8
Gw1_8_14 0 sum_h_14 in_8 vref -9.453503e-8
Gw1_9_14 0 sum_h_14 in_9 vref 2.850468e-7
Gw1_10_14 0 sum_h_14 in_10 vref 1.502845e-9
Gw1_11_14 0 sum_h_14 in_11 vref -8.241076e-8
Gw1_12_14 0 sum_h_14 in_12 vref -2.062344e-7
Gw1_13_14 0 sum_h_14 in_13 vref -2.738013e-8
Gw1_14_14 0 sum_h_14 in_14 vref -1.419030e-7
Gw1_15_14 0 sum_h_14 in_15 vref 1.739654e-7
Gw1_16_14 0 sum_h_14 in_16 vref -5.798282e-8
Gw1_17_14 0 sum_h_14 in_17 vref -1.032784e-8
Gw1_18_14 0 sum_h_14 in_18 vref 2.956190e-8
Gw1_19_14 0 sum_h_14 in_19 vref -8.868343e-9
Gw1_20_14 0 sum_h_14 in_20 vref -3.138692e-8
Gw1_21_14 0 sum_h_14 in_21 vref 9.667365e-8
Gw1_22_14 0 sum_h_14 in_22 vref 9.361760e-8
Gw1_23_14 0 sum_h_14 in_23 vref -5.462398e-9
Gw1_24_14 0 sum_h_14 in_24 vref 4.571033e-8
Gw1_25_14 0 sum_h_14 in_25 vref 1.347358e-8
Gw1_26_14 0 sum_h_14 in_26 vref 2.369911e-8
Gw1_27_14 0 sum_h_14 in_27 vref -9.373231e-9
Gw1_28_14 0 sum_h_14 in_28 vref 1.008953e-8
Gw1_29_14 0 sum_h_14 in_29 vref -7.922962e-8
Gw1_30_14 0 sum_h_14 in_30 vref 1.325186e-7
Gw1_31_14 0 sum_h_14 in_31 vref -8.120723e-8
Gw1_32_14 0 sum_h_14 in_32 vref 5.044917e-8
Gw1_33_14 0 sum_h_14 in_33 vref 3.857503e-8
Gw1_34_14 0 sum_h_14 in_34 vref 1.725028e-7
Gw1_35_14 0 sum_h_14 in_35 vref 5.786754e-8
Gw1_36_14 0 sum_h_14 in_36 vref -7.172731e-9
Gw1_37_14 0 sum_h_14 in_37 vref -3.151452e-8
Gw1_38_14 0 sum_h_14 in_38 vref 5.490831e-9
Gw1_39_14 0 sum_h_14 in_39 vref -1.446420e-7
Gw1_40_14 0 sum_h_14 in_40 vref 8.584924e-8
Gw1_41_14 0 sum_h_14 in_41 vref 7.523246e-8
Gw1_42_14 0 sum_h_14 in_42 vref 3.123473e-8
Gw1_43_14 0 sum_h_14 in_43 vref -9.852491e-8
Gw1_44_14 0 sum_h_14 in_44 vref -5.192807e-8
Gw1_45_14 0 sum_h_14 in_45 vref -2.197911e-7
Gw1_46_14 0 sum_h_14 in_46 vref -4.521705e-8
Gw1_47_14 0 sum_h_14 in_47 vref 1.126789e-7
Gw1_48_14 0 sum_h_14 in_48 vref -2.591007e-8
Gw1_0_15 0 sum_h_15 in_0 vref 5.041894e-8
Gw1_1_15 0 sum_h_15 in_1 vref -1.965414e-8
Gw1_2_15 0 sum_h_15 in_2 vref 1.230135e-7
Gw1_3_15 0 sum_h_15 in_3 vref 2.891046e-8
Gw1_4_15 0 sum_h_15 in_4 vref -5.694556e-10
Gw1_5_15 0 sum_h_15 in_5 vref 1.487650e-7
Gw1_6_15 0 sum_h_15 in_6 vref 4.732469e-8
Gw1_7_15 0 sum_h_15 in_7 vref -3.526956e-8
Gw1_8_15 0 sum_h_15 in_8 vref -4.805450e-8
Gw1_9_15 0 sum_h_15 in_9 vref -1.495938e-7
Gw1_10_15 0 sum_h_15 in_10 vref -8.784509e-8
Gw1_11_15 0 sum_h_15 in_11 vref 1.851491e-8
Gw1_12_15 0 sum_h_15 in_12 vref -3.357678e-9
Gw1_13_15 0 sum_h_15 in_13 vref -9.704515e-8
Gw1_14_15 0 sum_h_15 in_14 vref 7.335141e-8
Gw1_15_15 0 sum_h_15 in_15 vref -1.406360e-7
Gw1_16_15 0 sum_h_15 in_16 vref -1.411745e-7
Gw1_17_15 0 sum_h_15 in_17 vref 6.462995e-8
Gw1_18_15 0 sum_h_15 in_18 vref -7.008500e-9
Gw1_19_15 0 sum_h_15 in_19 vref -1.207113e-7
Gw1_20_15 0 sum_h_15 in_20 vref 2.240292e-8
Gw1_21_15 0 sum_h_15 in_21 vref -1.282156e-7
Gw1_22_15 0 sum_h_15 in_22 vref 1.905322e-9
Gw1_23_15 0 sum_h_15 in_23 vref -4.683337e-8
Gw1_24_15 0 sum_h_15 in_24 vref 5.484794e-9
Gw1_25_15 0 sum_h_15 in_25 vref 2.567225e-8
Gw1_26_15 0 sum_h_15 in_26 vref -5.788926e-8
Gw1_27_15 0 sum_h_15 in_27 vref 1.141409e-7
Gw1_28_15 0 sum_h_15 in_28 vref 5.169871e-8
Gw1_29_15 0 sum_h_15 in_29 vref 5.036640e-8
Gw1_30_15 0 sum_h_15 in_30 vref -8.749919e-8
Gw1_31_15 0 sum_h_15 in_31 vref 1.519906e-7
Gw1_32_15 0 sum_h_15 in_32 vref 1.194054e-7
Gw1_33_15 0 sum_h_15 in_33 vref 3.663088e-8
Gw1_34_15 0 sum_h_15 in_34 vref -3.237977e-8
Gw1_35_15 0 sum_h_15 in_35 vref 1.824584e-7
Gw1_36_15 0 sum_h_15 in_36 vref 4.995925e-8
Gw1_37_15 0 sum_h_15 in_37 vref 4.008950e-8
Gw1_38_15 0 sum_h_15 in_38 vref -8.846867e-8
Gw1_39_15 0 sum_h_15 in_39 vref 8.155912e-8
Gw1_40_15 0 sum_h_15 in_40 vref 2.044243e-7
Gw1_41_15 0 sum_h_15 in_41 vref -3.483516e-8
Gw1_42_15 0 sum_h_15 in_42 vref 1.833807e-8
Gw1_43_15 0 sum_h_15 in_43 vref -1.381414e-7
Gw1_44_15 0 sum_h_15 in_44 vref -2.282409e-7
Gw1_45_15 0 sum_h_15 in_45 vref -1.729482e-7
Gw1_46_15 0 sum_h_15 in_46 vref -1.400020e-7
Gw1_47_15 0 sum_h_15 in_47 vref -5.782702e-8
Gw1_48_15 0 sum_h_15 in_48 vref 7.947516e-8
Gw1_0_16 0 sum_h_16 in_0 vref -7.330785e-8
Gw1_1_16 0 sum_h_16 in_1 vref 1.334849e-8
Gw1_2_16 0 sum_h_16 in_2 vref -5.426893e-8
Gw1_3_16 0 sum_h_16 in_3 vref 7.916994e-8
Gw1_4_16 0 sum_h_16 in_4 vref 4.230278e-8
Gw1_5_16 0 sum_h_16 in_5 vref 9.337049e-9
Gw1_6_16 0 sum_h_16 in_6 vref 4.826678e-8
Gw1_7_16 0 sum_h_16 in_7 vref 8.635385e-9
Gw1_8_16 0 sum_h_16 in_8 vref -7.392381e-8
Gw1_9_16 0 sum_h_16 in_9 vref -3.496023e-8
Gw1_10_16 0 sum_h_16 in_10 vref 1.184776e-7
Gw1_11_16 0 sum_h_16 in_11 vref -3.615358e-8
Gw1_12_16 0 sum_h_16 in_12 vref 1.288120e-7
Gw1_13_16 0 sum_h_16 in_13 vref 5.413666e-8
Gw1_14_16 0 sum_h_16 in_14 vref -4.738893e-8
Gw1_15_16 0 sum_h_16 in_15 vref 6.291229e-8
Gw1_16_16 0 sum_h_16 in_16 vref -1.024604e-7
Gw1_17_16 0 sum_h_16 in_17 vref -1.713376e-8
Gw1_18_16 0 sum_h_16 in_18 vref 7.453424e-8
Gw1_19_16 0 sum_h_16 in_19 vref -1.645609e-7
Gw1_20_16 0 sum_h_16 in_20 vref -8.126474e-8
Gw1_21_16 0 sum_h_16 in_21 vref 1.518309e-7
Gw1_22_16 0 sum_h_16 in_22 vref -1.229609e-9
Gw1_23_16 0 sum_h_16 in_23 vref 1.422176e-8
Gw1_24_16 0 sum_h_16 in_24 vref 1.481139e-8
Gw1_25_16 0 sum_h_16 in_25 vref 1.863431e-7
Gw1_26_16 0 sum_h_16 in_26 vref 8.236218e-8
Gw1_27_16 0 sum_h_16 in_27 vref -1.348168e-7
Gw1_28_16 0 sum_h_16 in_28 vref 1.249494e-7
Gw1_29_16 0 sum_h_16 in_29 vref 1.475015e-7
Gw1_30_16 0 sum_h_16 in_30 vref -1.176926e-7
Gw1_31_16 0 sum_h_16 in_31 vref 7.366822e-8
Gw1_32_16 0 sum_h_16 in_32 vref 9.372796e-8
Gw1_33_16 0 sum_h_16 in_33 vref 1.761988e-7
Gw1_34_16 0 sum_h_16 in_34 vref 7.644451e-8
Gw1_35_16 0 sum_h_16 in_35 vref 1.051357e-7
Gw1_36_16 0 sum_h_16 in_36 vref -1.754360e-8
Gw1_37_16 0 sum_h_16 in_37 vref -4.552113e-8
Gw1_38_16 0 sum_h_16 in_38 vref 6.008643e-8
Gw1_39_16 0 sum_h_16 in_39 vref 8.886420e-8
Gw1_40_16 0 sum_h_16 in_40 vref -1.284673e-7
Gw1_41_16 0 sum_h_16 in_41 vref -3.887819e-8
Gw1_42_16 0 sum_h_16 in_42 vref 3.283559e-8
Gw1_43_16 0 sum_h_16 in_43 vref -8.321537e-10
Gw1_44_16 0 sum_h_16 in_44 vref 1.178904e-7
Gw1_45_16 0 sum_h_16 in_45 vref -1.980455e-8
Gw1_46_16 0 sum_h_16 in_46 vref 3.584448e-8
Gw1_47_16 0 sum_h_16 in_47 vref -1.174747e-8
Gw1_48_16 0 sum_h_16 in_48 vref -5.883830e-8
Gw1_0_17 0 sum_h_17 in_0 vref -1.277650e-7
Gw1_1_17 0 sum_h_17 in_1 vref 1.143418e-7
Gw1_2_17 0 sum_h_17 in_2 vref 2.991459e-8
Gw1_3_17 0 sum_h_17 in_3 vref 1.275091e-8
Gw1_4_17 0 sum_h_17 in_4 vref -1.105955e-7
Gw1_5_17 0 sum_h_17 in_5 vref -1.418224e-7
Gw1_6_17 0 sum_h_17 in_6 vref 1.213057e-7
Gw1_7_17 0 sum_h_17 in_7 vref 6.845861e-8
Gw1_8_17 0 sum_h_17 in_8 vref 9.024146e-8
Gw1_9_17 0 sum_h_17 in_9 vref -2.465935e-8
Gw1_10_17 0 sum_h_17 in_10 vref 3.207970e-8
Gw1_11_17 0 sum_h_17 in_11 vref -1.382728e-7
Gw1_12_17 0 sum_h_17 in_12 vref -1.071794e-7
Gw1_13_17 0 sum_h_17 in_13 vref -5.581140e-8
Gw1_14_17 0 sum_h_17 in_14 vref 1.511687e-7
Gw1_15_17 0 sum_h_17 in_15 vref 5.353089e-8
Gw1_16_17 0 sum_h_17 in_16 vref -3.117942e-8
Gw1_17_17 0 sum_h_17 in_17 vref 1.455104e-7
Gw1_18_17 0 sum_h_17 in_18 vref -1.160875e-7
Gw1_19_17 0 sum_h_17 in_19 vref 1.256222e-9
Gw1_20_17 0 sum_h_17 in_20 vref 7.403067e-8
Gw1_21_17 0 sum_h_17 in_21 vref -3.334823e-8
Gw1_22_17 0 sum_h_17 in_22 vref -1.565902e-7
Gw1_23_17 0 sum_h_17 in_23 vref -1.547900e-7
Gw1_24_17 0 sum_h_17 in_24 vref 1.594452e-7
Gw1_25_17 0 sum_h_17 in_25 vref 1.022786e-7
Gw1_26_17 0 sum_h_17 in_26 vref 1.432433e-7
Gw1_27_17 0 sum_h_17 in_27 vref 8.475352e-8
Gw1_28_17 0 sum_h_17 in_28 vref -2.128977e-8
Gw1_29_17 0 sum_h_17 in_29 vref 4.386861e-8
Gw1_30_17 0 sum_h_17 in_30 vref 3.222223e-8
Gw1_31_17 0 sum_h_17 in_31 vref -1.383562e-7
Gw1_32_17 0 sum_h_17 in_32 vref -8.769894e-8
Gw1_33_17 0 sum_h_17 in_33 vref -1.936567e-8
Gw1_34_17 0 sum_h_17 in_34 vref 9.448321e-8
Gw1_35_17 0 sum_h_17 in_35 vref -1.108526e-7
Gw1_36_17 0 sum_h_17 in_36 vref 8.064479e-8
Gw1_37_17 0 sum_h_17 in_37 vref 7.751086e-8
Gw1_38_17 0 sum_h_17 in_38 vref 2.808929e-8
Gw1_39_17 0 sum_h_17 in_39 vref 1.370871e-8
Gw1_40_17 0 sum_h_17 in_40 vref -4.108538e-8
Gw1_41_17 0 sum_h_17 in_41 vref -9.454783e-8
Gw1_42_17 0 sum_h_17 in_42 vref 6.208018e-8
Gw1_43_17 0 sum_h_17 in_43 vref -1.361378e-7
Gw1_44_17 0 sum_h_17 in_44 vref -1.003518e-7
Gw1_45_17 0 sum_h_17 in_45 vref -1.729603e-7
Gw1_46_17 0 sum_h_17 in_46 vref 3.374736e-8
Gw1_47_17 0 sum_h_17 in_47 vref 9.949179e-8
Gw1_48_17 0 sum_h_17 in_48 vref -9.260172e-8
Gw1_0_18 0 sum_h_18 in_0 vref 2.321944e-8
Gw1_1_18 0 sum_h_18 in_1 vref 3.081799e-8
Gw1_2_18 0 sum_h_18 in_2 vref -2.168486e-8
Gw1_3_18 0 sum_h_18 in_3 vref 6.400313e-8
Gw1_4_18 0 sum_h_18 in_4 vref 2.101091e-8
Gw1_5_18 0 sum_h_18 in_5 vref 2.152698e-8
Gw1_6_18 0 sum_h_18 in_6 vref 1.412441e-8
Gw1_7_18 0 sum_h_18 in_7 vref 1.975369e-8
Gw1_8_18 0 sum_h_18 in_8 vref -3.652965e-8
Gw1_9_18 0 sum_h_18 in_9 vref -2.494650e-7
Gw1_10_18 0 sum_h_18 in_10 vref -2.534950e-7
Gw1_11_18 0 sum_h_18 in_11 vref -3.858691e-8
Gw1_12_18 0 sum_h_18 in_12 vref -5.047090e-8
Gw1_13_18 0 sum_h_18 in_13 vref 8.583288e-9
Gw1_14_18 0 sum_h_18 in_14 vref -7.970222e-8
Gw1_15_18 0 sum_h_18 in_15 vref 3.550084e-8
Gw1_16_18 0 sum_h_18 in_16 vref 1.809048e-8
Gw1_17_18 0 sum_h_18 in_17 vref -9.407185e-9
Gw1_18_18 0 sum_h_18 in_18 vref -1.065520e-7
Gw1_19_18 0 sum_h_18 in_19 vref -1.543903e-8
Gw1_20_18 0 sum_h_18 in_20 vref 1.758648e-8
Gw1_21_18 0 sum_h_18 in_21 vref 7.543996e-8
Gw1_22_18 0 sum_h_18 in_22 vref 8.139931e-9
Gw1_23_18 0 sum_h_18 in_23 vref -7.609750e-8
Gw1_24_18 0 sum_h_18 in_24 vref 7.653870e-8
Gw1_25_18 0 sum_h_18 in_25 vref 7.366615e-8
Gw1_26_18 0 sum_h_18 in_26 vref 4.587599e-8
Gw1_27_18 0 sum_h_18 in_27 vref -6.945724e-8
Gw1_28_18 0 sum_h_18 in_28 vref 7.057807e-8
Gw1_29_18 0 sum_h_18 in_29 vref 2.862376e-8
Gw1_30_18 0 sum_h_18 in_30 vref -2.217459e-7
Gw1_31_18 0 sum_h_18 in_31 vref 9.294122e-8
Gw1_32_18 0 sum_h_18 in_32 vref 1.034271e-7
Gw1_33_18 0 sum_h_18 in_33 vref 9.809273e-8
Gw1_34_18 0 sum_h_18 in_34 vref 5.117280e-8
Gw1_35_18 0 sum_h_18 in_35 vref 8.216288e-8
Gw1_36_18 0 sum_h_18 in_36 vref 9.071891e-8
Gw1_37_18 0 sum_h_18 in_37 vref -1.167627e-7
Gw1_38_18 0 sum_h_18 in_38 vref 4.792747e-8
Gw1_39_18 0 sum_h_18 in_39 vref 5.162508e-8
Gw1_40_18 0 sum_h_18 in_40 vref 5.699710e-9
Gw1_41_18 0 sum_h_18 in_41 vref 1.069466e-7
Gw1_42_18 0 sum_h_18 in_42 vref -3.645041e-8
Gw1_43_18 0 sum_h_18 in_43 vref 7.887694e-8
Gw1_44_18 0 sum_h_18 in_44 vref 1.251309e-7
Gw1_45_18 0 sum_h_18 in_45 vref 5.535886e-8
Gw1_46_18 0 sum_h_18 in_46 vref -6.234549e-8
Gw1_47_18 0 sum_h_18 in_47 vref 1.907539e-8
Gw1_48_18 0 sum_h_18 in_48 vref 7.594726e-8
Gw1_0_19 0 sum_h_19 in_0 vref -2.537059e-8
Gw1_1_19 0 sum_h_19 in_1 vref -6.321078e-8
Gw1_2_19 0 sum_h_19 in_2 vref 1.414927e-7
Gw1_3_19 0 sum_h_19 in_3 vref 9.435589e-8
Gw1_4_19 0 sum_h_19 in_4 vref -1.234809e-7
Gw1_5_19 0 sum_h_19 in_5 vref 9.587488e-8
Gw1_6_19 0 sum_h_19 in_6 vref 6.075738e-8
Gw1_7_19 0 sum_h_19 in_7 vref 1.054320e-7
Gw1_8_19 0 sum_h_19 in_8 vref -2.463582e-8
Gw1_9_19 0 sum_h_19 in_9 vref 1.009629e-7
Gw1_10_19 0 sum_h_19 in_10 vref 1.463549e-7
Gw1_11_19 0 sum_h_19 in_11 vref 1.010158e-8
Gw1_12_19 0 sum_h_19 in_12 vref -4.709541e-8
Gw1_13_19 0 sum_h_19 in_13 vref -3.684105e-8
Gw1_14_19 0 sum_h_19 in_14 vref -9.420090e-8
Gw1_15_19 0 sum_h_19 in_15 vref -3.447805e-8
Gw1_16_19 0 sum_h_19 in_16 vref -7.884223e-8
Gw1_17_19 0 sum_h_19 in_17 vref 3.617097e-8
Gw1_18_19 0 sum_h_19 in_18 vref 4.438728e-8
Gw1_19_19 0 sum_h_19 in_19 vref 1.810564e-8
Gw1_20_19 0 sum_h_19 in_20 vref 1.014337e-7
Gw1_21_19 0 sum_h_19 in_21 vref -7.836173e-8
Gw1_22_19 0 sum_h_19 in_22 vref -2.908604e-7
Gw1_23_19 0 sum_h_19 in_23 vref -2.095864e-7
Gw1_24_19 0 sum_h_19 in_24 vref -1.492812e-7
Gw1_25_19 0 sum_h_19 in_25 vref -8.651742e-8
Gw1_26_19 0 sum_h_19 in_26 vref 3.737311e-8
Gw1_27_19 0 sum_h_19 in_27 vref 5.931143e-8
Gw1_28_19 0 sum_h_19 in_28 vref 1.156709e-7
Gw1_29_19 0 sum_h_19 in_29 vref 9.473675e-8
Gw1_30_19 0 sum_h_19 in_30 vref 1.002801e-7
Gw1_31_19 0 sum_h_19 in_31 vref 1.429045e-7
Gw1_32_19 0 sum_h_19 in_32 vref -6.236847e-8
Gw1_33_19 0 sum_h_19 in_33 vref -3.685838e-8
Gw1_34_19 0 sum_h_19 in_34 vref -1.383063e-8
Gw1_35_19 0 sum_h_19 in_35 vref -3.869207e-8
Gw1_36_19 0 sum_h_19 in_36 vref 4.121467e-8
Gw1_37_19 0 sum_h_19 in_37 vref 1.054830e-7
Gw1_38_19 0 sum_h_19 in_38 vref 3.901981e-8
Gw1_39_19 0 sum_h_19 in_39 vref 1.738780e-8
Gw1_40_19 0 sum_h_19 in_40 vref 1.354314e-7
Gw1_41_19 0 sum_h_19 in_41 vref 9.950730e-8
Gw1_42_19 0 sum_h_19 in_42 vref -6.530918e-9
Gw1_43_19 0 sum_h_19 in_43 vref -7.638062e-8
Gw1_44_19 0 sum_h_19 in_44 vref -1.739707e-7
Gw1_45_19 0 sum_h_19 in_45 vref 9.183111e-8
Gw1_46_19 0 sum_h_19 in_46 vref 4.321107e-8
Gw1_47_19 0 sum_h_19 in_47 vref -9.286326e-9
Gw1_48_19 0 sum_h_19 in_48 vref 7.533099e-8
Gw1_0_20 0 sum_h_20 in_0 vref -9.497388e-8
Gw1_1_20 0 sum_h_20 in_1 vref -7.013384e-8
Gw1_2_20 0 sum_h_20 in_2 vref -9.270192e-8
Gw1_3_20 0 sum_h_20 in_3 vref 3.563461e-8
Gw1_4_20 0 sum_h_20 in_4 vref -8.048122e-9
Gw1_5_20 0 sum_h_20 in_5 vref 1.247767e-7
Gw1_6_20 0 sum_h_20 in_6 vref -7.311224e-8
Gw1_7_20 0 sum_h_20 in_7 vref -4.466599e-8
Gw1_8_20 0 sum_h_20 in_8 vref 2.253716e-8
Gw1_9_20 0 sum_h_20 in_9 vref -2.819215e-8
Gw1_10_20 0 sum_h_20 in_10 vref 4.428812e-8
Gw1_11_20 0 sum_h_20 in_11 vref -9.071417e-8
Gw1_12_20 0 sum_h_20 in_12 vref -5.315101e-8
Gw1_13_20 0 sum_h_20 in_13 vref 1.270840e-7
Gw1_14_20 0 sum_h_20 in_14 vref -4.500059e-8
Gw1_15_20 0 sum_h_20 in_15 vref 8.290892e-8
Gw1_16_20 0 sum_h_20 in_16 vref -2.675138e-8
Gw1_17_20 0 sum_h_20 in_17 vref 6.560546e-8
Gw1_18_20 0 sum_h_20 in_18 vref -1.514184e-8
Gw1_19_20 0 sum_h_20 in_19 vref 1.696764e-7
Gw1_20_20 0 sum_h_20 in_20 vref 1.224230e-7
Gw1_21_20 0 sum_h_20 in_21 vref 1.495396e-7
Gw1_22_20 0 sum_h_20 in_22 vref 2.228647e-7
Gw1_23_20 0 sum_h_20 in_23 vref 2.224403e-7
Gw1_24_20 0 sum_h_20 in_24 vref -2.427912e-7
Gw1_25_20 0 sum_h_20 in_25 vref 3.406867e-8
Gw1_26_20 0 sum_h_20 in_26 vref -9.956979e-8
Gw1_27_20 0 sum_h_20 in_27 vref -1.809864e-10
Gw1_28_20 0 sum_h_20 in_28 vref 1.619115e-8
Gw1_29_20 0 sum_h_20 in_29 vref -3.042332e-8
Gw1_30_20 0 sum_h_20 in_30 vref -2.140302e-7
Gw1_31_20 0 sum_h_20 in_31 vref -9.173482e-8
Gw1_32_20 0 sum_h_20 in_32 vref 1.888707e-8
Gw1_33_20 0 sum_h_20 in_33 vref -1.747725e-7
Gw1_34_20 0 sum_h_20 in_34 vref 7.499094e-9
Gw1_35_20 0 sum_h_20 in_35 vref 1.147628e-7
Gw1_36_20 0 sum_h_20 in_36 vref -1.740717e-7
Gw1_37_20 0 sum_h_20 in_37 vref -5.985330e-8
Gw1_38_20 0 sum_h_20 in_38 vref 1.123865e-8
Gw1_39_20 0 sum_h_20 in_39 vref 1.305677e-8
Gw1_40_20 0 sum_h_20 in_40 vref 1.828549e-7
Gw1_41_20 0 sum_h_20 in_41 vref -8.873612e-8
Gw1_42_20 0 sum_h_20 in_42 vref -1.219152e-7
Gw1_43_20 0 sum_h_20 in_43 vref 1.571608e-8
Gw1_44_20 0 sum_h_20 in_44 vref -1.009821e-7
Gw1_45_20 0 sum_h_20 in_45 vref 3.251014e-8
Gw1_46_20 0 sum_h_20 in_46 vref 2.952541e-8
Gw1_47_20 0 sum_h_20 in_47 vref -1.139213e-7
Gw1_48_20 0 sum_h_20 in_48 vref 1.066329e-7
Gw1_0_21 0 sum_h_21 in_0 vref 6.299320e-8
Gw1_1_21 0 sum_h_21 in_1 vref -5.511719e-8
Gw1_2_21 0 sum_h_21 in_2 vref -9.017924e-8
Gw1_3_21 0 sum_h_21 in_3 vref 2.114674e-7
Gw1_4_21 0 sum_h_21 in_4 vref 6.400491e-8
Gw1_5_21 0 sum_h_21 in_5 vref -2.524215e-8
Gw1_6_21 0 sum_h_21 in_6 vref -1.413336e-7
Gw1_7_21 0 sum_h_21 in_7 vref 6.535753e-8
Gw1_8_21 0 sum_h_21 in_8 vref 1.028403e-7
Gw1_9_21 0 sum_h_21 in_9 vref 1.831879e-7
Gw1_10_21 0 sum_h_21 in_10 vref 3.770781e-8
Gw1_11_21 0 sum_h_21 in_11 vref 8.326086e-8
Gw1_12_21 0 sum_h_21 in_12 vref -1.577881e-7
Gw1_13_21 0 sum_h_21 in_13 vref 6.686057e-9
Gw1_14_21 0 sum_h_21 in_14 vref -1.037775e-7
Gw1_15_21 0 sum_h_21 in_15 vref -2.878165e-7
Gw1_16_21 0 sum_h_21 in_16 vref -3.740352e-7
Gw1_17_21 0 sum_h_21 in_17 vref -1.418590e-7
Gw1_18_21 0 sum_h_21 in_18 vref 9.636859e-8
Gw1_19_21 0 sum_h_21 in_19 vref -1.689594e-7
Gw1_20_21 0 sum_h_21 in_20 vref -4.684301e-8
Gw1_21_21 0 sum_h_21 in_21 vref 5.519891e-8
Gw1_22_21 0 sum_h_21 in_22 vref 6.240465e-8
Gw1_23_21 0 sum_h_21 in_23 vref 1.584097e-7
Gw1_24_21 0 sum_h_21 in_24 vref 9.680541e-8
Gw1_25_21 0 sum_h_21 in_25 vref -5.587259e-8
Gw1_26_21 0 sum_h_21 in_26 vref 1.326767e-8
Gw1_27_21 0 sum_h_21 in_27 vref 4.711861e-8
Gw1_28_21 0 sum_h_21 in_28 vref 1.022415e-7
Gw1_29_21 0 sum_h_21 in_29 vref 5.229359e-9
Gw1_30_21 0 sum_h_21 in_30 vref -7.854778e-8
Gw1_31_21 0 sum_h_21 in_31 vref -2.784410e-9
Gw1_32_21 0 sum_h_21 in_32 vref -1.429415e-8
Gw1_33_21 0 sum_h_21 in_33 vref 1.100859e-7
Gw1_34_21 0 sum_h_21 in_34 vref 9.544137e-8
Gw1_35_21 0 sum_h_21 in_35 vref -1.031426e-7
Gw1_36_21 0 sum_h_21 in_36 vref 4.715769e-8
Gw1_37_21 0 sum_h_21 in_37 vref -1.310938e-8
Gw1_38_21 0 sum_h_21 in_38 vref -1.142200e-8
Gw1_39_21 0 sum_h_21 in_39 vref -2.849501e-8
Gw1_40_21 0 sum_h_21 in_40 vref -9.085866e-8
Gw1_41_21 0 sum_h_21 in_41 vref 7.060814e-10
Gw1_42_21 0 sum_h_21 in_42 vref -8.188227e-9
Gw1_43_21 0 sum_h_21 in_43 vref 1.991372e-8
Gw1_44_21 0 sum_h_21 in_44 vref -8.929971e-9
Gw1_45_21 0 sum_h_21 in_45 vref -4.001410e-8
Gw1_46_21 0 sum_h_21 in_46 vref -3.902420e-8
Gw1_47_21 0 sum_h_21 in_47 vref -1.493998e-7
Gw1_48_21 0 sum_h_21 in_48 vref 7.597004e-8
Gw1_0_22 0 sum_h_22 in_0 vref 3.735305e-9
Gw1_1_22 0 sum_h_22 in_1 vref -9.796373e-9
Gw1_2_22 0 sum_h_22 in_2 vref 6.885826e-8
Gw1_3_22 0 sum_h_22 in_3 vref 5.687217e-8
Gw1_4_22 0 sum_h_22 in_4 vref -3.500362e-8
Gw1_5_22 0 sum_h_22 in_5 vref 2.565230e-8
Gw1_6_22 0 sum_h_22 in_6 vref 3.866805e-8
Gw1_7_22 0 sum_h_22 in_7 vref -2.990346e-8
Gw1_8_22 0 sum_h_22 in_8 vref 3.983912e-8
Gw1_9_22 0 sum_h_22 in_9 vref 1.688060e-7
Gw1_10_22 0 sum_h_22 in_10 vref -7.520394e-8
Gw1_11_22 0 sum_h_22 in_11 vref -1.352767e-8
Gw1_12_22 0 sum_h_22 in_12 vref 1.421102e-7
Gw1_13_22 0 sum_h_22 in_13 vref -6.015682e-8
Gw1_14_22 0 sum_h_22 in_14 vref -2.610814e-8
Gw1_15_22 0 sum_h_22 in_15 vref 1.694815e-7
Gw1_16_22 0 sum_h_22 in_16 vref 1.008832e-7
Gw1_17_22 0 sum_h_22 in_17 vref -8.505233e-8
Gw1_18_22 0 sum_h_22 in_18 vref 7.560728e-8
Gw1_19_22 0 sum_h_22 in_19 vref -7.084964e-8
Gw1_20_22 0 sum_h_22 in_20 vref -1.589991e-8
Gw1_21_22 0 sum_h_22 in_21 vref 2.367726e-8
Gw1_22_22 0 sum_h_22 in_22 vref 2.984227e-7
Gw1_23_22 0 sum_h_22 in_23 vref -9.424162e-8
Gw1_24_22 0 sum_h_22 in_24 vref -1.470567e-7
Gw1_25_22 0 sum_h_22 in_25 vref -4.636934e-8
Gw1_26_22 0 sum_h_22 in_26 vref 1.436893e-7
Gw1_27_22 0 sum_h_22 in_27 vref 8.989058e-8
Gw1_28_22 0 sum_h_22 in_28 vref -1.178765e-7
Gw1_29_22 0 sum_h_22 in_29 vref 3.807220e-8
Gw1_30_22 0 sum_h_22 in_30 vref 4.776545e-8
Gw1_31_22 0 sum_h_22 in_31 vref -7.527034e-8
Gw1_32_22 0 sum_h_22 in_32 vref -4.379275e-8
Gw1_33_22 0 sum_h_22 in_33 vref 1.041593e-7
Gw1_34_22 0 sum_h_22 in_34 vref 1.038887e-7
Gw1_35_22 0 sum_h_22 in_35 vref -1.328856e-7
Gw1_36_22 0 sum_h_22 in_36 vref -9.072330e-8
Gw1_37_22 0 sum_h_22 in_37 vref -8.264860e-8
Gw1_38_22 0 sum_h_22 in_38 vref -1.219390e-7
Gw1_39_22 0 sum_h_22 in_39 vref 1.679814e-7
Gw1_40_22 0 sum_h_22 in_40 vref 6.480196e-8
Gw1_41_22 0 sum_h_22 in_41 vref 9.595475e-8
Gw1_42_22 0 sum_h_22 in_42 vref -1.195723e-7
Gw1_43_22 0 sum_h_22 in_43 vref -1.258695e-7
Gw1_44_22 0 sum_h_22 in_44 vref 9.965287e-8
Gw1_45_22 0 sum_h_22 in_45 vref -3.544211e-8
Gw1_46_22 0 sum_h_22 in_46 vref 2.306299e-8
Gw1_47_22 0 sum_h_22 in_47 vref -8.276012e-8
Gw1_48_22 0 sum_h_22 in_48 vref 2.030384e-8
Gw1_0_23 0 sum_h_23 in_0 vref 4.258370e-9
Gw1_1_23 0 sum_h_23 in_1 vref 1.072770e-7
Gw1_2_23 0 sum_h_23 in_2 vref -1.344841e-7
Gw1_3_23 0 sum_h_23 in_3 vref 3.748596e-8
Gw1_4_23 0 sum_h_23 in_4 vref 2.618133e-8
Gw1_5_23 0 sum_h_23 in_5 vref 1.172056e-7
Gw1_6_23 0 sum_h_23 in_6 vref 1.002323e-7
Gw1_7_23 0 sum_h_23 in_7 vref -4.043399e-9
Gw1_8_23 0 sum_h_23 in_8 vref 4.448934e-8
Gw1_9_23 0 sum_h_23 in_9 vref 6.392918e-8
Gw1_10_23 0 sum_h_23 in_10 vref 9.942093e-8
Gw1_11_23 0 sum_h_23 in_11 vref -2.487590e-8
Gw1_12_23 0 sum_h_23 in_12 vref -1.410836e-7
Gw1_13_23 0 sum_h_23 in_13 vref 1.019002e-8
Gw1_14_23 0 sum_h_23 in_14 vref 2.275563e-9
Gw1_15_23 0 sum_h_23 in_15 vref 1.408160e-7
Gw1_16_23 0 sum_h_23 in_16 vref 1.091080e-9
Gw1_17_23 0 sum_h_23 in_17 vref -1.075541e-7
Gw1_18_23 0 sum_h_23 in_18 vref -3.078284e-8
Gw1_19_23 0 sum_h_23 in_19 vref -7.371257e-8
Gw1_20_23 0 sum_h_23 in_20 vref 3.105801e-8
Gw1_21_23 0 sum_h_23 in_21 vref 5.706267e-8
Gw1_22_23 0 sum_h_23 in_22 vref -4.843694e-8
Gw1_23_23 0 sum_h_23 in_23 vref -1.447252e-9
Gw1_24_23 0 sum_h_23 in_24 vref -1.473452e-7
Gw1_25_23 0 sum_h_23 in_25 vref 8.998997e-8
Gw1_26_23 0 sum_h_23 in_26 vref 1.806803e-7
Gw1_27_23 0 sum_h_23 in_27 vref -3.913322e-9
Gw1_28_23 0 sum_h_23 in_28 vref 2.355675e-8
Gw1_29_23 0 sum_h_23 in_29 vref -2.258681e-8
Gw1_30_23 0 sum_h_23 in_30 vref -1.784655e-7
Gw1_31_23 0 sum_h_23 in_31 vref -1.977580e-7
Gw1_32_23 0 sum_h_23 in_32 vref 2.019844e-7
Gw1_33_23 0 sum_h_23 in_33 vref 1.549489e-8
Gw1_34_23 0 sum_h_23 in_34 vref -1.194104e-7
Gw1_35_23 0 sum_h_23 in_35 vref -1.269891e-7
Gw1_36_23 0 sum_h_23 in_36 vref -7.922414e-8
Gw1_37_23 0 sum_h_23 in_37 vref 9.285174e-8
Gw1_38_23 0 sum_h_23 in_38 vref 1.085788e-7
Gw1_39_23 0 sum_h_23 in_39 vref -7.587097e-8
Gw1_40_23 0 sum_h_23 in_40 vref -1.435085e-7
Gw1_41_23 0 sum_h_23 in_41 vref -1.055285e-7
Gw1_42_23 0 sum_h_23 in_42 vref 5.311617e-8
Gw1_43_23 0 sum_h_23 in_43 vref -1.120858e-7
Gw1_44_23 0 sum_h_23 in_44 vref 2.016896e-8
Gw1_45_23 0 sum_h_23 in_45 vref 4.938869e-8
Gw1_46_23 0 sum_h_23 in_46 vref 2.092493e-7
Gw1_47_23 0 sum_h_23 in_47 vref 1.784281e-7
Gw1_48_23 0 sum_h_23 in_48 vref -1.307518e-7
Gw1_0_24 0 sum_h_24 in_0 vref 7.492506e-8
Gw1_1_24 0 sum_h_24 in_1 vref 1.071042e-7
Gw1_2_24 0 sum_h_24 in_2 vref 4.052474e-8
Gw1_3_24 0 sum_h_24 in_3 vref -8.161550e-9
Gw1_4_24 0 sum_h_24 in_4 vref 1.037452e-7
Gw1_5_24 0 sum_h_24 in_5 vref -3.514344e-8
Gw1_6_24 0 sum_h_24 in_6 vref 1.231456e-9
Gw1_7_24 0 sum_h_24 in_7 vref -2.671073e-9
Gw1_8_24 0 sum_h_24 in_8 vref -1.091579e-7
Gw1_9_24 0 sum_h_24 in_9 vref -1.729680e-8
Gw1_10_24 0 sum_h_24 in_10 vref 8.726944e-8
Gw1_11_24 0 sum_h_24 in_11 vref 1.137565e-7
Gw1_12_24 0 sum_h_24 in_12 vref 6.678982e-8
Gw1_13_24 0 sum_h_24 in_13 vref -1.021053e-7
Gw1_14_24 0 sum_h_24 in_14 vref -2.739538e-9
Gw1_15_24 0 sum_h_24 in_15 vref -3.896047e-8
Gw1_16_24 0 sum_h_24 in_16 vref -1.423548e-7
Gw1_17_24 0 sum_h_24 in_17 vref -4.687644e-8
Gw1_18_24 0 sum_h_24 in_18 vref -5.122764e-8
Gw1_19_24 0 sum_h_24 in_19 vref 1.751172e-7
Gw1_20_24 0 sum_h_24 in_20 vref -1.500883e-7
Gw1_21_24 0 sum_h_24 in_21 vref -5.752583e-8
Gw1_22_24 0 sum_h_24 in_22 vref 8.103965e-8
Gw1_23_24 0 sum_h_24 in_23 vref 1.758357e-7
Gw1_24_24 0 sum_h_24 in_24 vref -7.027832e-8
Gw1_25_24 0 sum_h_24 in_25 vref -8.842110e-8
Gw1_26_24 0 sum_h_24 in_26 vref 1.239377e-9
Gw1_27_24 0 sum_h_24 in_27 vref 6.084832e-8
Gw1_28_24 0 sum_h_24 in_28 vref -9.926521e-8
Gw1_29_24 0 sum_h_24 in_29 vref 1.763603e-7
Gw1_30_24 0 sum_h_24 in_30 vref -1.126113e-7
Gw1_31_24 0 sum_h_24 in_31 vref -4.717219e-8
Gw1_32_24 0 sum_h_24 in_32 vref 5.482033e-8
Gw1_33_24 0 sum_h_24 in_33 vref 5.845028e-8
Gw1_34_24 0 sum_h_24 in_34 vref -7.990312e-8
Gw1_35_24 0 sum_h_24 in_35 vref 7.440792e-9
Gw1_36_24 0 sum_h_24 in_36 vref 1.292936e-7
Gw1_37_24 0 sum_h_24 in_37 vref -6.325373e-8
Gw1_38_24 0 sum_h_24 in_38 vref -1.667457e-7
Gw1_39_24 0 sum_h_24 in_39 vref 4.938439e-8
Gw1_40_24 0 sum_h_24 in_40 vref -8.338869e-8
Gw1_41_24 0 sum_h_24 in_41 vref 6.700066e-8
Gw1_42_24 0 sum_h_24 in_42 vref 1.403050e-8
Gw1_43_24 0 sum_h_24 in_43 vref -5.045858e-8
Gw1_44_24 0 sum_h_24 in_44 vref 4.011051e-8
Gw1_45_24 0 sum_h_24 in_45 vref -1.539474e-8
Gw1_46_24 0 sum_h_24 in_46 vref -3.655899e-11
Gw1_47_24 0 sum_h_24 in_47 vref -3.189293e-8
Gw1_48_24 0 sum_h_24 in_48 vref -2.996065e-8
Gw1_0_25 0 sum_h_25 in_0 vref -7.789078e-8
Gw1_1_25 0 sum_h_25 in_1 vref 1.429788e-7
Gw1_2_25 0 sum_h_25 in_2 vref -7.800237e-8
Gw1_3_25 0 sum_h_25 in_3 vref -9.638334e-8
Gw1_4_25 0 sum_h_25 in_4 vref 3.834230e-8
Gw1_5_25 0 sum_h_25 in_5 vref 2.940677e-9
Gw1_6_25 0 sum_h_25 in_6 vref 1.144287e-7
Gw1_7_25 0 sum_h_25 in_7 vref 5.151126e-8
Gw1_8_25 0 sum_h_25 in_8 vref -4.115878e-8
Gw1_9_25 0 sum_h_25 in_9 vref -1.816174e-7
Gw1_10_25 0 sum_h_25 in_10 vref -2.668099e-8
Gw1_11_25 0 sum_h_25 in_11 vref -1.492860e-8
Gw1_12_25 0 sum_h_25 in_12 vref 2.163687e-8
Gw1_13_25 0 sum_h_25 in_13 vref 1.699897e-7
Gw1_14_25 0 sum_h_25 in_14 vref 2.844520e-8
Gw1_15_25 0 sum_h_25 in_15 vref 2.229353e-8
Gw1_16_25 0 sum_h_25 in_16 vref -3.265398e-7
Gw1_17_25 0 sum_h_25 in_17 vref 1.473150e-7
Gw1_18_25 0 sum_h_25 in_18 vref 2.503412e-8
Gw1_19_25 0 sum_h_25 in_19 vref 5.067604e-8
Gw1_20_25 0 sum_h_25 in_20 vref 1.796198e-8
Gw1_21_25 0 sum_h_25 in_21 vref -8.453722e-8
Gw1_22_25 0 sum_h_25 in_22 vref -2.840413e-8
Gw1_23_25 0 sum_h_25 in_23 vref -4.577369e-8
Gw1_24_25 0 sum_h_25 in_24 vref 1.629039e-7
Gw1_25_25 0 sum_h_25 in_25 vref -8.427992e-8
Gw1_26_25 0 sum_h_25 in_26 vref -3.033176e-8
Gw1_27_25 0 sum_h_25 in_27 vref -1.317475e-7
Gw1_28_25 0 sum_h_25 in_28 vref -4.389456e-8
Gw1_29_25 0 sum_h_25 in_29 vref -1.330761e-7
Gw1_30_25 0 sum_h_25 in_30 vref -2.997583e-9
Gw1_31_25 0 sum_h_25 in_31 vref 2.265221e-8
Gw1_32_25 0 sum_h_25 in_32 vref -8.277050e-9
Gw1_33_25 0 sum_h_25 in_33 vref -1.513106e-7
Gw1_34_25 0 sum_h_25 in_34 vref 8.823216e-8
Gw1_35_25 0 sum_h_25 in_35 vref 1.145610e-8
Gw1_36_25 0 sum_h_25 in_36 vref -1.856026e-8
Gw1_37_25 0 sum_h_25 in_37 vref 4.415620e-8
Gw1_38_25 0 sum_h_25 in_38 vref -9.951230e-8
Gw1_39_25 0 sum_h_25 in_39 vref -1.758817e-7
Gw1_40_25 0 sum_h_25 in_40 vref -1.575863e-7
Gw1_41_25 0 sum_h_25 in_41 vref -5.374381e-9
Gw1_42_25 0 sum_h_25 in_42 vref 2.677813e-8
Gw1_43_25 0 sum_h_25 in_43 vref 1.406991e-8
Gw1_44_25 0 sum_h_25 in_44 vref 6.605839e-8
Gw1_45_25 0 sum_h_25 in_45 vref 5.301346e-8
Gw1_46_25 0 sum_h_25 in_46 vref -8.529721e-8
Gw1_47_25 0 sum_h_25 in_47 vref -3.998787e-8
Gw1_48_25 0 sum_h_25 in_48 vref 6.112177e-8
Gw1_0_26 0 sum_h_26 in_0 vref -4.916515e-8
Gw1_1_26 0 sum_h_26 in_1 vref 5.524806e-8
Gw1_2_26 0 sum_h_26 in_2 vref 4.142199e-8
Gw1_3_26 0 sum_h_26 in_3 vref -7.983817e-8
Gw1_4_26 0 sum_h_26 in_4 vref 1.031245e-8
Gw1_5_26 0 sum_h_26 in_5 vref -2.095188e-8
Gw1_6_26 0 sum_h_26 in_6 vref -1.459350e-7
Gw1_7_26 0 sum_h_26 in_7 vref -7.198209e-8
Gw1_8_26 0 sum_h_26 in_8 vref 5.790955e-8
Gw1_9_26 0 sum_h_26 in_9 vref -2.878843e-8
Gw1_10_26 0 sum_h_26 in_10 vref -4.875276e-8
Gw1_11_26 0 sum_h_26 in_11 vref -8.007419e-8
Gw1_12_26 0 sum_h_26 in_12 vref 1.667215e-7
Gw1_13_26 0 sum_h_26 in_13 vref 1.425909e-9
Gw1_14_26 0 sum_h_26 in_14 vref -4.172226e-8
Gw1_15_26 0 sum_h_26 in_15 vref 7.386388e-8
Gw1_16_26 0 sum_h_26 in_16 vref 1.349241e-7
Gw1_17_26 0 sum_h_26 in_17 vref 1.768819e-8
Gw1_18_26 0 sum_h_26 in_18 vref -9.336203e-8
Gw1_19_26 0 sum_h_26 in_19 vref -1.024850e-7
Gw1_20_26 0 sum_h_26 in_20 vref 3.531342e-8
Gw1_21_26 0 sum_h_26 in_21 vref -5.673320e-8
Gw1_22_26 0 sum_h_26 in_22 vref -2.610689e-7
Gw1_23_26 0 sum_h_26 in_23 vref -2.067358e-7
Gw1_24_26 0 sum_h_26 in_24 vref -3.256102e-8
Gw1_25_26 0 sum_h_26 in_25 vref -6.129014e-8
Gw1_26_26 0 sum_h_26 in_26 vref 5.552187e-8
Gw1_27_26 0 sum_h_26 in_27 vref -9.145480e-8
Gw1_28_26 0 sum_h_26 in_28 vref 8.036641e-8
Gw1_29_26 0 sum_h_26 in_29 vref -6.200543e-8
Gw1_30_26 0 sum_h_26 in_30 vref 1.815365e-9
Gw1_31_26 0 sum_h_26 in_31 vref 2.204392e-7
Gw1_32_26 0 sum_h_26 in_32 vref -9.733585e-8
Gw1_33_26 0 sum_h_26 in_33 vref -6.227092e-8
Gw1_34_26 0 sum_h_26 in_34 vref 9.149620e-8
Gw1_35_26 0 sum_h_26 in_35 vref -1.510668e-7
Gw1_36_26 0 sum_h_26 in_36 vref -3.034983e-8
Gw1_37_26 0 sum_h_26 in_37 vref 1.190934e-7
Gw1_38_26 0 sum_h_26 in_38 vref 5.128683e-8
Gw1_39_26 0 sum_h_26 in_39 vref 1.105245e-7
Gw1_40_26 0 sum_h_26 in_40 vref 3.924351e-8
Gw1_41_26 0 sum_h_26 in_41 vref -6.174038e-8
Gw1_42_26 0 sum_h_26 in_42 vref -1.345113e-7
Gw1_43_26 0 sum_h_26 in_43 vref -1.032210e-8
Gw1_44_26 0 sum_h_26 in_44 vref 2.698335e-8
Gw1_45_26 0 sum_h_26 in_45 vref 3.532586e-8
Gw1_46_26 0 sum_h_26 in_46 vref 3.437232e-9
Gw1_47_26 0 sum_h_26 in_47 vref -1.507917e-7
Gw1_48_26 0 sum_h_26 in_48 vref 5.757333e-8
Gw1_0_27 0 sum_h_27 in_0 vref 1.517194e-7
Gw1_1_27 0 sum_h_27 in_1 vref -3.284515e-8
Gw1_2_27 0 sum_h_27 in_2 vref -1.440976e-7
Gw1_3_27 0 sum_h_27 in_3 vref -5.881735e-8
Gw1_4_27 0 sum_h_27 in_4 vref 1.073162e-7
Gw1_5_27 0 sum_h_27 in_5 vref 8.487980e-8
Gw1_6_27 0 sum_h_27 in_6 vref 1.099378e-7
Gw1_7_27 0 sum_h_27 in_7 vref 6.610474e-8
Gw1_8_27 0 sum_h_27 in_8 vref 9.116576e-8
Gw1_9_27 0 sum_h_27 in_9 vref -4.197207e-8
Gw1_10_27 0 sum_h_27 in_10 vref -8.311622e-8
Gw1_11_27 0 sum_h_27 in_11 vref -8.707404e-8
Gw1_12_27 0 sum_h_27 in_12 vref 4.775099e-8
Gw1_13_27 0 sum_h_27 in_13 vref -1.674511e-9
Gw1_14_27 0 sum_h_27 in_14 vref -1.131770e-7
Gw1_15_27 0 sum_h_27 in_15 vref 2.543385e-8
Gw1_16_27 0 sum_h_27 in_16 vref -4.047344e-8
Gw1_17_27 0 sum_h_27 in_17 vref -2.870836e-8
Gw1_18_27 0 sum_h_27 in_18 vref 9.971353e-9
Gw1_19_27 0 sum_h_27 in_19 vref -1.209356e-7
Gw1_20_27 0 sum_h_27 in_20 vref 3.396172e-8
Gw1_21_27 0 sum_h_27 in_21 vref 1.311023e-7
Gw1_22_27 0 sum_h_27 in_22 vref -5.918708e-8
Gw1_23_27 0 sum_h_27 in_23 vref 1.191465e-7
Gw1_24_27 0 sum_h_27 in_24 vref 2.348182e-8
Gw1_25_27 0 sum_h_27 in_25 vref 8.879266e-8
Gw1_26_27 0 sum_h_27 in_26 vref 1.053396e-7
Gw1_27_27 0 sum_h_27 in_27 vref 3.589902e-8
Gw1_28_27 0 sum_h_27 in_28 vref -3.484077e-9
Gw1_29_27 0 sum_h_27 in_29 vref 3.738643e-8
Gw1_30_27 0 sum_h_27 in_30 vref -1.112620e-7
Gw1_31_27 0 sum_h_27 in_31 vref 1.391109e-7
Gw1_32_27 0 sum_h_27 in_32 vref 3.305251e-8
Gw1_33_27 0 sum_h_27 in_33 vref -6.488386e-8
Gw1_34_27 0 sum_h_27 in_34 vref -4.099169e-10
Gw1_35_27 0 sum_h_27 in_35 vref -3.628697e-8
Gw1_36_27 0 sum_h_27 in_36 vref -1.219337e-7
Gw1_37_27 0 sum_h_27 in_37 vref -2.047615e-7
Gw1_38_27 0 sum_h_27 in_38 vref 1.417424e-7
Gw1_39_27 0 sum_h_27 in_39 vref -8.747676e-9
Gw1_40_27 0 sum_h_27 in_40 vref 1.050941e-8
Gw1_41_27 0 sum_h_27 in_41 vref -7.057272e-8
Gw1_42_27 0 sum_h_27 in_42 vref -7.218787e-8
Gw1_43_27 0 sum_h_27 in_43 vref 9.570979e-8
Gw1_44_27 0 sum_h_27 in_44 vref -1.243615e-7
Gw1_45_27 0 sum_h_27 in_45 vref 5.864932e-8
Gw1_46_27 0 sum_h_27 in_46 vref -1.864071e-9
Gw1_47_27 0 sum_h_27 in_47 vref 1.283755e-7
Gw1_48_27 0 sum_h_27 in_48 vref 5.712065e-8
Gw1_0_28 0 sum_h_28 in_0 vref 1.117072e-8
Gw1_1_28 0 sum_h_28 in_1 vref 1.229789e-7
Gw1_2_28 0 sum_h_28 in_2 vref -3.279091e-8
Gw1_3_28 0 sum_h_28 in_3 vref -1.158671e-7
Gw1_4_28 0 sum_h_28 in_4 vref 1.287697e-8
Gw1_5_28 0 sum_h_28 in_5 vref 1.202646e-7
Gw1_6_28 0 sum_h_28 in_6 vref -2.671458e-8
Gw1_7_28 0 sum_h_28 in_7 vref -8.455898e-8
Gw1_8_28 0 sum_h_28 in_8 vref 1.574478e-7
Gw1_9_28 0 sum_h_28 in_9 vref -2.524397e-8
Gw1_10_28 0 sum_h_28 in_10 vref 4.491370e-8
Gw1_11_28 0 sum_h_28 in_11 vref -1.171697e-8
Gw1_12_28 0 sum_h_28 in_12 vref -2.075556e-7
Gw1_13_28 0 sum_h_28 in_13 vref -2.720308e-8
Gw1_14_28 0 sum_h_28 in_14 vref 9.814570e-8
Gw1_15_28 0 sum_h_28 in_15 vref 2.957180e-8
Gw1_16_28 0 sum_h_28 in_16 vref -3.936769e-8
Gw1_17_28 0 sum_h_28 in_17 vref 1.473205e-7
Gw1_18_28 0 sum_h_28 in_18 vref -4.097219e-8
Gw1_19_28 0 sum_h_28 in_19 vref -1.388640e-7
Gw1_20_28 0 sum_h_28 in_20 vref -5.488016e-8
Gw1_21_28 0 sum_h_28 in_21 vref -5.601641e-8
Gw1_22_28 0 sum_h_28 in_22 vref -1.291199e-7
Gw1_23_28 0 sum_h_28 in_23 vref 3.441208e-8
Gw1_24_28 0 sum_h_28 in_24 vref 1.631362e-7
Gw1_25_28 0 sum_h_28 in_25 vref -7.421943e-8
Gw1_26_28 0 sum_h_28 in_26 vref 1.417386e-7
Gw1_27_28 0 sum_h_28 in_27 vref -8.489261e-9
Gw1_28_28 0 sum_h_28 in_28 vref -3.531626e-8
Gw1_29_28 0 sum_h_28 in_29 vref 6.141385e-9
Gw1_30_28 0 sum_h_28 in_30 vref -1.227119e-7
Gw1_31_28 0 sum_h_28 in_31 vref -5.061984e-8
Gw1_32_28 0 sum_h_28 in_32 vref -2.241439e-7
Gw1_33_28 0 sum_h_28 in_33 vref 8.335120e-8
Gw1_34_28 0 sum_h_28 in_34 vref -5.490386e-8
Gw1_35_28 0 sum_h_28 in_35 vref 1.355541e-7
Gw1_36_28 0 sum_h_28 in_36 vref -1.958727e-7
Gw1_37_28 0 sum_h_28 in_37 vref -7.907336e-8
Gw1_38_28 0 sum_h_28 in_38 vref 5.290939e-8
Gw1_39_28 0 sum_h_28 in_39 vref -1.639664e-7
Gw1_40_28 0 sum_h_28 in_40 vref -1.650286e-9
Gw1_41_28 0 sum_h_28 in_41 vref -6.936781e-8
Gw1_42_28 0 sum_h_28 in_42 vref -2.634531e-8
Gw1_43_28 0 sum_h_28 in_43 vref 4.576985e-8
Gw1_44_28 0 sum_h_28 in_44 vref 9.760810e-8
Gw1_45_28 0 sum_h_28 in_45 vref -6.425047e-9
Gw1_46_28 0 sum_h_28 in_46 vref -8.806161e-8
Gw1_47_28 0 sum_h_28 in_47 vref 9.483544e-8
Gw1_48_28 0 sum_h_28 in_48 vref 3.263857e-8
Gw1_0_29 0 sum_h_29 in_0 vref 9.517239e-8
Gw1_1_29 0 sum_h_29 in_1 vref 3.080796e-8
Gw1_2_29 0 sum_h_29 in_2 vref 6.644253e-8
Gw1_3_29 0 sum_h_29 in_3 vref 4.988041e-8
Gw1_4_29 0 sum_h_29 in_4 vref 2.919879e-8
Gw1_5_29 0 sum_h_29 in_5 vref 9.745339e-8
Gw1_6_29 0 sum_h_29 in_6 vref 8.054979e-8
Gw1_7_29 0 sum_h_29 in_7 vref -1.090628e-7
Gw1_8_29 0 sum_h_29 in_8 vref -7.222700e-8
Gw1_9_29 0 sum_h_29 in_9 vref 1.129925e-7
Gw1_10_29 0 sum_h_29 in_10 vref -9.686359e-8
Gw1_11_29 0 sum_h_29 in_11 vref 5.246998e-8
Gw1_12_29 0 sum_h_29 in_12 vref 1.516605e-7
Gw1_13_29 0 sum_h_29 in_13 vref 5.199101e-8
Gw1_14_29 0 sum_h_29 in_14 vref 8.110780e-8
Gw1_15_29 0 sum_h_29 in_15 vref 2.059192e-8
Gw1_16_29 0 sum_h_29 in_16 vref -6.050634e-8
Gw1_17_29 0 sum_h_29 in_17 vref -9.606828e-8
Gw1_18_29 0 sum_h_29 in_18 vref 4.083160e-8
Gw1_19_29 0 sum_h_29 in_19 vref -1.593849e-7
Gw1_20_29 0 sum_h_29 in_20 vref 5.837999e-8
Gw1_21_29 0 sum_h_29 in_21 vref 4.080320e-9
Gw1_22_29 0 sum_h_29 in_22 vref -8.952375e-8
Gw1_23_29 0 sum_h_29 in_23 vref -4.240461e-8
Gw1_24_29 0 sum_h_29 in_24 vref 1.418596e-8
Gw1_25_29 0 sum_h_29 in_25 vref -1.250591e-7
Gw1_26_29 0 sum_h_29 in_26 vref -3.517858e-8
Gw1_27_29 0 sum_h_29 in_27 vref -9.590426e-8
Gw1_28_29 0 sum_h_29 in_28 vref -3.537617e-8
Gw1_29_29 0 sum_h_29 in_29 vref -2.223819e-8
Gw1_30_29 0 sum_h_29 in_30 vref -1.091265e-7
Gw1_31_29 0 sum_h_29 in_31 vref 1.249030e-7
Gw1_32_29 0 sum_h_29 in_32 vref 2.051904e-7
Gw1_33_29 0 sum_h_29 in_33 vref -8.958079e-8
Gw1_34_29 0 sum_h_29 in_34 vref -4.432692e-8
Gw1_35_29 0 sum_h_29 in_35 vref 4.195967e-8
Gw1_36_29 0 sum_h_29 in_36 vref -1.035142e-7
Gw1_37_29 0 sum_h_29 in_37 vref -1.075023e-7
Gw1_38_29 0 sum_h_29 in_38 vref 1.322755e-7
Gw1_39_29 0 sum_h_29 in_39 vref 7.029636e-8
Gw1_40_29 0 sum_h_29 in_40 vref -5.662670e-8
Gw1_41_29 0 sum_h_29 in_41 vref 6.466936e-8
Gw1_42_29 0 sum_h_29 in_42 vref -6.441430e-8
Gw1_43_29 0 sum_h_29 in_43 vref -1.462342e-7
Gw1_44_29 0 sum_h_29 in_44 vref -1.028189e-7
Gw1_45_29 0 sum_h_29 in_45 vref -1.374178e-7
Gw1_46_29 0 sum_h_29 in_46 vref -1.190618e-7
Gw1_47_29 0 sum_h_29 in_47 vref -2.774938e-8
Gw1_48_29 0 sum_h_29 in_48 vref 1.241378e-7
Gw1_0_30 0 sum_h_30 in_0 vref -9.691278e-8
Gw1_1_30 0 sum_h_30 in_1 vref -2.654628e-8
Gw1_2_30 0 sum_h_30 in_2 vref 9.904093e-9
Gw1_3_30 0 sum_h_30 in_3 vref 1.319399e-7
Gw1_4_30 0 sum_h_30 in_4 vref 2.165339e-8
Gw1_5_30 0 sum_h_30 in_5 vref -7.219846e-8
Gw1_6_30 0 sum_h_30 in_6 vref -3.149221e-8
Gw1_7_30 0 sum_h_30 in_7 vref -6.865639e-8
Gw1_8_30 0 sum_h_30 in_8 vref -1.786282e-8
Gw1_9_30 0 sum_h_30 in_9 vref 1.117999e-10
Gw1_10_30 0 sum_h_30 in_10 vref 1.374479e-8
Gw1_11_30 0 sum_h_30 in_11 vref 1.883262e-8
Gw1_12_30 0 sum_h_30 in_12 vref 2.760678e-9
Gw1_13_30 0 sum_h_30 in_13 vref 5.356003e-8
Gw1_14_30 0 sum_h_30 in_14 vref -7.714750e-8
Gw1_15_30 0 sum_h_30 in_15 vref -6.918658e-8
Gw1_16_30 0 sum_h_30 in_16 vref -3.941694e-8
Gw1_17_30 0 sum_h_30 in_17 vref 5.877510e-9
Gw1_18_30 0 sum_h_30 in_18 vref 1.384480e-8
Gw1_19_30 0 sum_h_30 in_19 vref -6.449469e-8
Gw1_20_30 0 sum_h_30 in_20 vref -1.168718e-7
Gw1_21_30 0 sum_h_30 in_21 vref 1.204581e-7
Gw1_22_30 0 sum_h_30 in_22 vref 3.650360e-8
Gw1_23_30 0 sum_h_30 in_23 vref -3.545787e-8
Gw1_24_30 0 sum_h_30 in_24 vref -6.208987e-8
Gw1_25_30 0 sum_h_30 in_25 vref 1.428240e-7
Gw1_26_30 0 sum_h_30 in_26 vref 4.789801e-8
Gw1_27_30 0 sum_h_30 in_27 vref 8.610097e-8
Gw1_28_30 0 sum_h_30 in_28 vref 5.449726e-8
Gw1_29_30 0 sum_h_30 in_29 vref 3.678054e-8
Gw1_30_30 0 sum_h_30 in_30 vref 7.608227e-8
Gw1_31_30 0 sum_h_30 in_31 vref -8.030511e-8
Gw1_32_30 0 sum_h_30 in_32 vref 1.208096e-7
Gw1_33_30 0 sum_h_30 in_33 vref 1.339859e-7
Gw1_34_30 0 sum_h_30 in_34 vref -8.130145e-9
Gw1_35_30 0 sum_h_30 in_35 vref 4.894064e-8
Gw1_36_30 0 sum_h_30 in_36 vref -6.880851e-8
Gw1_37_30 0 sum_h_30 in_37 vref -1.555339e-7
Gw1_38_30 0 sum_h_30 in_38 vref 8.783314e-8
Gw1_39_30 0 sum_h_30 in_39 vref 1.315102e-7
Gw1_40_30 0 sum_h_30 in_40 vref -6.313928e-8
Gw1_41_30 0 sum_h_30 in_41 vref -1.099245e-7
Gw1_42_30 0 sum_h_30 in_42 vref -9.980803e-8
Gw1_43_30 0 sum_h_30 in_43 vref 1.677902e-7
Gw1_44_30 0 sum_h_30 in_44 vref 1.023946e-7
Gw1_45_30 0 sum_h_30 in_45 vref 1.528433e-7
Gw1_46_30 0 sum_h_30 in_46 vref 1.136121e-7
Gw1_47_30 0 sum_h_30 in_47 vref 4.181756e-8
Gw1_48_30 0 sum_h_30 in_48 vref 7.334003e-8
Gw1_0_31 0 sum_h_31 in_0 vref 5.552589e-8
Gw1_1_31 0 sum_h_31 in_1 vref 3.273707e-9
Gw1_2_31 0 sum_h_31 in_2 vref 5.031371e-8
Gw1_3_31 0 sum_h_31 in_3 vref -1.403806e-7
Gw1_4_31 0 sum_h_31 in_4 vref -1.047036e-7
Gw1_5_31 0 sum_h_31 in_5 vref 8.145046e-8
Gw1_6_31 0 sum_h_31 in_6 vref 6.703324e-8
Gw1_7_31 0 sum_h_31 in_7 vref -4.183891e-8
Gw1_8_31 0 sum_h_31 in_8 vref 6.286578e-8
Gw1_9_31 0 sum_h_31 in_9 vref -7.319566e-8
Gw1_10_31 0 sum_h_31 in_10 vref -3.725675e-8
Gw1_11_31 0 sum_h_31 in_11 vref 7.825782e-8
Gw1_12_31 0 sum_h_31 in_12 vref 1.118268e-8
Gw1_13_31 0 sum_h_31 in_13 vref -1.895181e-8
Gw1_14_31 0 sum_h_31 in_14 vref 8.030693e-8
Gw1_15_31 0 sum_h_31 in_15 vref 1.184832e-7
Gw1_16_31 0 sum_h_31 in_16 vref 1.661009e-7
Gw1_17_31 0 sum_h_31 in_17 vref -6.769132e-10
Gw1_18_31 0 sum_h_31 in_18 vref 1.052437e-8
Gw1_19_31 0 sum_h_31 in_19 vref 9.708398e-8
Gw1_20_31 0 sum_h_31 in_20 vref -1.324357e-7
Gw1_21_31 0 sum_h_31 in_21 vref -5.311974e-10
Gw1_22_31 0 sum_h_31 in_22 vref 1.559514e-8
Gw1_23_31 0 sum_h_31 in_23 vref -1.689784e-7
Gw1_24_31 0 sum_h_31 in_24 vref -1.141326e-7
Gw1_25_31 0 sum_h_31 in_25 vref -5.923524e-8
Gw1_26_31 0 sum_h_31 in_26 vref -1.555062e-7
Gw1_27_31 0 sum_h_31 in_27 vref 8.674056e-8
Gw1_28_31 0 sum_h_31 in_28 vref -1.360698e-8
Gw1_29_31 0 sum_h_31 in_29 vref -1.439906e-8
Gw1_30_31 0 sum_h_31 in_30 vref -3.886172e-8
Gw1_31_31 0 sum_h_31 in_31 vref 1.549327e-7
Gw1_32_31 0 sum_h_31 in_32 vref -4.707031e-9
Gw1_33_31 0 sum_h_31 in_33 vref 1.116870e-7
Gw1_34_31 0 sum_h_31 in_34 vref -3.396925e-8
Gw1_35_31 0 sum_h_31 in_35 vref -8.238428e-8
Gw1_36_31 0 sum_h_31 in_36 vref -1.282768e-8
Gw1_37_31 0 sum_h_31 in_37 vref 5.848590e-8
Gw1_38_31 0 sum_h_31 in_38 vref 1.020441e-7
Gw1_39_31 0 sum_h_31 in_39 vref -2.883119e-8
Gw1_40_31 0 sum_h_31 in_40 vref -6.356441e-8
Gw1_41_31 0 sum_h_31 in_41 vref 1.024897e-7
Gw1_42_31 0 sum_h_31 in_42 vref -4.652071e-8
Gw1_43_31 0 sum_h_31 in_43 vref 1.169725e-7
Gw1_44_31 0 sum_h_31 in_44 vref -1.610762e-7
Gw1_45_31 0 sum_h_31 in_45 vref -2.098478e-8
Gw1_46_31 0 sum_h_31 in_46 vref 1.875931e-7
Gw1_47_31 0 sum_h_31 in_47 vref -1.979209e-8
Gw1_48_31 0 sum_h_31 in_48 vref 1.231411e-7
Gw1_0_32 0 sum_h_32 in_0 vref 2.718932e-8
Gw1_1_32 0 sum_h_32 in_1 vref -9.210317e-9
Gw1_2_32 0 sum_h_32 in_2 vref -2.681755e-8
Gw1_3_32 0 sum_h_32 in_3 vref -1.122110e-7
Gw1_4_32 0 sum_h_32 in_4 vref -1.747042e-7
Gw1_5_32 0 sum_h_32 in_5 vref -3.947934e-8
Gw1_6_32 0 sum_h_32 in_6 vref -8.162338e-8
Gw1_7_32 0 sum_h_32 in_7 vref -8.943398e-8
Gw1_8_32 0 sum_h_32 in_8 vref 4.835354e-9
Gw1_9_32 0 sum_h_32 in_9 vref -9.839199e-8
Gw1_10_32 0 sum_h_32 in_10 vref -4.341244e-8
Gw1_11_32 0 sum_h_32 in_11 vref 6.786808e-8
Gw1_12_32 0 sum_h_32 in_12 vref 2.029136e-7
Gw1_13_32 0 sum_h_32 in_13 vref -7.182523e-8
Gw1_14_32 0 sum_h_32 in_14 vref -1.832463e-7
Gw1_15_32 0 sum_h_32 in_15 vref 4.084538e-8
Gw1_16_32 0 sum_h_32 in_16 vref 6.511129e-8
Gw1_17_32 0 sum_h_32 in_17 vref -1.180714e-8
Gw1_18_32 0 sum_h_32 in_18 vref -1.537433e-7
Gw1_19_32 0 sum_h_32 in_19 vref 2.512701e-8
Gw1_20_32 0 sum_h_32 in_20 vref 1.582822e-7
Gw1_21_32 0 sum_h_32 in_21 vref -8.502327e-8
Gw1_22_32 0 sum_h_32 in_22 vref 1.149251e-7
Gw1_23_32 0 sum_h_32 in_23 vref 2.941834e-8
Gw1_24_32 0 sum_h_32 in_24 vref 8.081505e-8
Gw1_25_32 0 sum_h_32 in_25 vref 3.487325e-8
Gw1_26_32 0 sum_h_32 in_26 vref -6.738527e-8
Gw1_27_32 0 sum_h_32 in_27 vref -1.375859e-7
Gw1_28_32 0 sum_h_32 in_28 vref -1.308180e-7
Gw1_29_32 0 sum_h_32 in_29 vref 9.932324e-8
Gw1_30_32 0 sum_h_32 in_30 vref 6.780527e-8
Gw1_31_32 0 sum_h_32 in_31 vref 3.875640e-8
Gw1_32_32 0 sum_h_32 in_32 vref -1.024496e-7
Gw1_33_32 0 sum_h_32 in_33 vref -6.848311e-8
Gw1_34_32 0 sum_h_32 in_34 vref 8.381933e-8
Gw1_35_32 0 sum_h_32 in_35 vref -1.053826e-7
Gw1_36_32 0 sum_h_32 in_36 vref -4.685754e-9
Gw1_37_32 0 sum_h_32 in_37 vref -1.227454e-7
Gw1_38_32 0 sum_h_32 in_38 vref 9.644688e-8
Gw1_39_32 0 sum_h_32 in_39 vref -3.964094e-8
Gw1_40_32 0 sum_h_32 in_40 vref 1.691503e-8
Gw1_41_32 0 sum_h_32 in_41 vref -6.246346e-8
Gw1_42_32 0 sum_h_32 in_42 vref 1.029259e-7
Gw1_43_32 0 sum_h_32 in_43 vref -1.083287e-7
Gw1_44_32 0 sum_h_32 in_44 vref -1.211644e-8
Gw1_45_32 0 sum_h_32 in_45 vref -2.950763e-9
Gw1_46_32 0 sum_h_32 in_46 vref 6.964019e-8
Gw1_47_32 0 sum_h_32 in_47 vref 7.781146e-8
Gw1_48_32 0 sum_h_32 in_48 vref -7.690640e-8
Gw1_0_33 0 sum_h_33 in_0 vref -5.854026e-8
Gw1_1_33 0 sum_h_33 in_1 vref 1.163332e-7
Gw1_2_33 0 sum_h_33 in_2 vref 1.898283e-8
Gw1_3_33 0 sum_h_33 in_3 vref -9.465263e-8
Gw1_4_33 0 sum_h_33 in_4 vref 4.701110e-8
Gw1_5_33 0 sum_h_33 in_5 vref 8.261188e-8
Gw1_6_33 0 sum_h_33 in_6 vref -1.540943e-8
Gw1_7_33 0 sum_h_33 in_7 vref -1.247984e-7
Gw1_8_33 0 sum_h_33 in_8 vref 1.124184e-7
Gw1_9_33 0 sum_h_33 in_9 vref -9.387984e-9
Gw1_10_33 0 sum_h_33 in_10 vref 4.233517e-8
Gw1_11_33 0 sum_h_33 in_11 vref -6.982279e-8
Gw1_12_33 0 sum_h_33 in_12 vref -6.954723e-8
Gw1_13_33 0 sum_h_33 in_13 vref -1.457421e-7
Gw1_14_33 0 sum_h_33 in_14 vref -7.742507e-8
Gw1_15_33 0 sum_h_33 in_15 vref 8.814660e-8
Gw1_16_33 0 sum_h_33 in_16 vref -2.456907e-7
Gw1_17_33 0 sum_h_33 in_17 vref 3.655996e-8
Gw1_18_33 0 sum_h_33 in_18 vref 2.838019e-8
Gw1_19_33 0 sum_h_33 in_19 vref -2.806689e-8
Gw1_20_33 0 sum_h_33 in_20 vref -1.395874e-7
Gw1_21_33 0 sum_h_33 in_21 vref 9.075119e-8
Gw1_22_33 0 sum_h_33 in_22 vref -6.623102e-8
Gw1_23_33 0 sum_h_33 in_23 vref 5.659390e-8
Gw1_24_33 0 sum_h_33 in_24 vref 1.388502e-7
Gw1_25_33 0 sum_h_33 in_25 vref -7.350335e-8
Gw1_26_33 0 sum_h_33 in_26 vref 3.728587e-8
Gw1_27_33 0 sum_h_33 in_27 vref 7.638568e-9
Gw1_28_33 0 sum_h_33 in_28 vref 1.009560e-7
Gw1_29_33 0 sum_h_33 in_29 vref 8.519095e-8
Gw1_30_33 0 sum_h_33 in_30 vref 9.363565e-8
Gw1_31_33 0 sum_h_33 in_31 vref 4.153849e-8
Gw1_32_33 0 sum_h_33 in_32 vref 7.008407e-8
Gw1_33_33 0 sum_h_33 in_33 vref 1.328302e-7
Gw1_34_33 0 sum_h_33 in_34 vref 3.963504e-8
Gw1_35_33 0 sum_h_33 in_35 vref -3.142931e-8
Gw1_36_33 0 sum_h_33 in_36 vref -3.866188e-8
Gw1_37_33 0 sum_h_33 in_37 vref 1.251104e-7
Gw1_38_33 0 sum_h_33 in_38 vref 9.499066e-10
Gw1_39_33 0 sum_h_33 in_39 vref -3.569610e-8
Gw1_40_33 0 sum_h_33 in_40 vref -6.100917e-8
Gw1_41_33 0 sum_h_33 in_41 vref -7.922090e-8
Gw1_42_33 0 sum_h_33 in_42 vref 1.052902e-7
Gw1_43_33 0 sum_h_33 in_43 vref -5.134809e-10
Gw1_44_33 0 sum_h_33 in_44 vref -1.216330e-7
Gw1_45_33 0 sum_h_33 in_45 vref -8.616597e-8
Gw1_46_33 0 sum_h_33 in_46 vref -1.101705e-7
Gw1_47_33 0 sum_h_33 in_47 vref -8.540056e-8
Gw1_48_33 0 sum_h_33 in_48 vref 1.183682e-8
Gw1_0_34 0 sum_h_34 in_0 vref 1.273751e-7
Gw1_1_34 0 sum_h_34 in_1 vref -7.989783e-8
Gw1_2_34 0 sum_h_34 in_2 vref -6.061616e-8
Gw1_3_34 0 sum_h_34 in_3 vref -1.414725e-7
Gw1_4_34 0 sum_h_34 in_4 vref -4.105937e-8
Gw1_5_34 0 sum_h_34 in_5 vref 2.767753e-10
Gw1_6_34 0 sum_h_34 in_6 vref 6.326066e-8
Gw1_7_34 0 sum_h_34 in_7 vref 1.259369e-7
Gw1_8_34 0 sum_h_34 in_8 vref -7.172841e-8
Gw1_9_34 0 sum_h_34 in_9 vref -3.657240e-8
Gw1_10_34 0 sum_h_34 in_10 vref 7.509873e-8
Gw1_11_34 0 sum_h_34 in_11 vref -3.248037e-7
Gw1_12_34 0 sum_h_34 in_12 vref 4.870029e-8
Gw1_13_34 0 sum_h_34 in_13 vref 1.288971e-7
Gw1_14_34 0 sum_h_34 in_14 vref -1.309607e-7
Gw1_15_34 0 sum_h_34 in_15 vref 4.136499e-8
Gw1_16_34 0 sum_h_34 in_16 vref -3.821927e-8
Gw1_17_34 0 sum_h_34 in_17 vref 1.548608e-7
Gw1_18_34 0 sum_h_34 in_18 vref -3.802723e-7
Gw1_19_34 0 sum_h_34 in_19 vref 2.498689e-7
Gw1_20_34 0 sum_h_34 in_20 vref -7.954425e-8
Gw1_21_34 0 sum_h_34 in_21 vref 8.149782e-8
Gw1_22_34 0 sum_h_34 in_22 vref 2.433290e-8
Gw1_23_34 0 sum_h_34 in_23 vref 5.207953e-8
Gw1_24_34 0 sum_h_34 in_24 vref -7.211320e-8
Gw1_25_34 0 sum_h_34 in_25 vref -1.045853e-7
Gw1_26_34 0 sum_h_34 in_26 vref 6.119178e-8
Gw1_27_34 0 sum_h_34 in_27 vref -1.373542e-7
Gw1_28_34 0 sum_h_34 in_28 vref 9.971352e-8
Gw1_29_34 0 sum_h_34 in_29 vref 7.311911e-8
Gw1_30_34 0 sum_h_34 in_30 vref 6.359955e-8
Gw1_31_34 0 sum_h_34 in_31 vref -1.945515e-8
Gw1_32_34 0 sum_h_34 in_32 vref 5.673153e-8
Gw1_33_34 0 sum_h_34 in_33 vref -9.268212e-9
Gw1_34_34 0 sum_h_34 in_34 vref -1.619512e-8
Gw1_35_34 0 sum_h_34 in_35 vref -1.089044e-7
Gw1_36_34 0 sum_h_34 in_36 vref 6.308124e-8
Gw1_37_34 0 sum_h_34 in_37 vref -1.538209e-8
Gw1_38_34 0 sum_h_34 in_38 vref -1.773544e-8
Gw1_39_34 0 sum_h_34 in_39 vref -3.121313e-8
Gw1_40_34 0 sum_h_34 in_40 vref 6.995061e-8
Gw1_41_34 0 sum_h_34 in_41 vref -3.245173e-8
Gw1_42_34 0 sum_h_34 in_42 vref -2.534168e-8
Gw1_43_34 0 sum_h_34 in_43 vref -5.484614e-8
Gw1_44_34 0 sum_h_34 in_44 vref 1.595665e-7
Gw1_45_34 0 sum_h_34 in_45 vref -3.216372e-8
Gw1_46_34 0 sum_h_34 in_46 vref -1.831772e-8
Gw1_47_34 0 sum_h_34 in_47 vref 1.041636e-8
Gw1_48_34 0 sum_h_34 in_48 vref -6.290372e-8
Gw1_0_35 0 sum_h_35 in_0 vref 7.745964e-8
Gw1_1_35 0 sum_h_35 in_1 vref 1.207933e-8
Gw1_2_35 0 sum_h_35 in_2 vref -6.071940e-8
Gw1_3_35 0 sum_h_35 in_3 vref 3.582902e-9
Gw1_4_35 0 sum_h_35 in_4 vref 2.643360e-8
Gw1_5_35 0 sum_h_35 in_5 vref -5.550610e-8
Gw1_6_35 0 sum_h_35 in_6 vref -3.422506e-8
Gw1_7_35 0 sum_h_35 in_7 vref -7.195536e-8
Gw1_8_35 0 sum_h_35 in_8 vref 4.686771e-9
Gw1_9_35 0 sum_h_35 in_9 vref 8.216692e-8
Gw1_10_35 0 sum_h_35 in_10 vref -9.436334e-8
Gw1_11_35 0 sum_h_35 in_11 vref 6.970129e-8
Gw1_12_35 0 sum_h_35 in_12 vref -5.127832e-8
Gw1_13_35 0 sum_h_35 in_13 vref -1.190599e-7
Gw1_14_35 0 sum_h_35 in_14 vref -2.092104e-8
Gw1_15_35 0 sum_h_35 in_15 vref 2.797520e-8
Gw1_16_35 0 sum_h_35 in_16 vref -6.934533e-8
Gw1_17_35 0 sum_h_35 in_17 vref 1.157164e-7
Gw1_18_35 0 sum_h_35 in_18 vref 5.074586e-8
Gw1_19_35 0 sum_h_35 in_19 vref -3.342906e-7
Gw1_20_35 0 sum_h_35 in_20 vref -2.290447e-8
Gw1_21_35 0 sum_h_35 in_21 vref -6.714311e-8
Gw1_22_35 0 sum_h_35 in_22 vref -7.038607e-8
Gw1_23_35 0 sum_h_35 in_23 vref -1.122137e-7
Gw1_24_35 0 sum_h_35 in_24 vref -1.022734e-8
Gw1_25_35 0 sum_h_35 in_25 vref -1.933577e-7
Gw1_26_35 0 sum_h_35 in_26 vref -2.686991e-8
Gw1_27_35 0 sum_h_35 in_27 vref 8.013044e-9
Gw1_28_35 0 sum_h_35 in_28 vref 1.211516e-7
Gw1_29_35 0 sum_h_35 in_29 vref 9.644405e-9
Gw1_30_35 0 sum_h_35 in_30 vref -2.612891e-8
Gw1_31_35 0 sum_h_35 in_31 vref -1.473035e-7
Gw1_32_35 0 sum_h_35 in_32 vref 1.599642e-7
Gw1_33_35 0 sum_h_35 in_33 vref -5.397365e-9
Gw1_34_35 0 sum_h_35 in_34 vref -1.499098e-7
Gw1_35_35 0 sum_h_35 in_35 vref 1.611625e-7
Gw1_36_35 0 sum_h_35 in_36 vref -3.561058e-8
Gw1_37_35 0 sum_h_35 in_37 vref 1.094347e-7
Gw1_38_35 0 sum_h_35 in_38 vref -6.815579e-8
Gw1_39_35 0 sum_h_35 in_39 vref 1.307835e-7
Gw1_40_35 0 sum_h_35 in_40 vref 9.884633e-8
Gw1_41_35 0 sum_h_35 in_41 vref -1.029183e-7
Gw1_42_35 0 sum_h_35 in_42 vref 1.487474e-7
Gw1_43_35 0 sum_h_35 in_43 vref -9.209507e-8
Gw1_44_35 0 sum_h_35 in_44 vref -4.304373e-8
Gw1_45_35 0 sum_h_35 in_45 vref -2.319949e-7
Gw1_46_35 0 sum_h_35 in_46 vref -2.167024e-9
Gw1_47_35 0 sum_h_35 in_47 vref -6.859118e-8
Gw1_48_35 0 sum_h_35 in_48 vref -1.202039e-7
Gw1_0_36 0 sum_h_36 in_0 vref 7.921132e-8
Gw1_1_36 0 sum_h_36 in_1 vref -8.220866e-8
Gw1_2_36 0 sum_h_36 in_2 vref -1.234781e-8
Gw1_3_36 0 sum_h_36 in_3 vref 2.461899e-8
Gw1_4_36 0 sum_h_36 in_4 vref 7.332487e-8
Gw1_5_36 0 sum_h_36 in_5 vref -1.729404e-8
Gw1_6_36 0 sum_h_36 in_6 vref 3.382905e-8
Gw1_7_36 0 sum_h_36 in_7 vref 9.509152e-8
Gw1_8_36 0 sum_h_36 in_8 vref -4.592939e-8
Gw1_9_36 0 sum_h_36 in_9 vref -5.050317e-8
Gw1_10_36 0 sum_h_36 in_10 vref 4.653494e-8
Gw1_11_36 0 sum_h_36 in_11 vref 7.148207e-8
Gw1_12_36 0 sum_h_36 in_12 vref -6.431585e-8
Gw1_13_36 0 sum_h_36 in_13 vref -1.394878e-7
Gw1_14_36 0 sum_h_36 in_14 vref 6.211548e-9
Gw1_15_36 0 sum_h_36 in_15 vref 1.747391e-8
Gw1_16_36 0 sum_h_36 in_16 vref 1.288670e-7
Gw1_17_36 0 sum_h_36 in_17 vref -3.492420e-10
Gw1_18_36 0 sum_h_36 in_18 vref -4.030945e-8
Gw1_19_36 0 sum_h_36 in_19 vref 3.968494e-8
Gw1_20_36 0 sum_h_36 in_20 vref 3.664995e-8
Gw1_21_36 0 sum_h_36 in_21 vref 6.241605e-8
Gw1_22_36 0 sum_h_36 in_22 vref 1.014636e-7
Gw1_23_36 0 sum_h_36 in_23 vref -8.144202e-8
Gw1_24_36 0 sum_h_36 in_24 vref -2.182725e-7
Gw1_25_36 0 sum_h_36 in_25 vref -1.409189e-7
Gw1_26_36 0 sum_h_36 in_26 vref -1.251134e-8
Gw1_27_36 0 sum_h_36 in_27 vref 1.194788e-7
Gw1_28_36 0 sum_h_36 in_28 vref -1.091949e-7
Gw1_29_36 0 sum_h_36 in_29 vref 9.403153e-8
Gw1_30_36 0 sum_h_36 in_30 vref 1.020764e-7
Gw1_31_36 0 sum_h_36 in_31 vref 2.602352e-8
Gw1_32_36 0 sum_h_36 in_32 vref -3.518103e-8
Gw1_33_36 0 sum_h_36 in_33 vref -7.926089e-8
Gw1_34_36 0 sum_h_36 in_34 vref 1.858528e-7
Gw1_35_36 0 sum_h_36 in_35 vref 2.737848e-9
Gw1_36_36 0 sum_h_36 in_36 vref 7.586932e-8
Gw1_37_36 0 sum_h_36 in_37 vref 1.610022e-7
Gw1_38_36 0 sum_h_36 in_38 vref 7.694398e-8
Gw1_39_36 0 sum_h_36 in_39 vref 3.891788e-8
Gw1_40_36 0 sum_h_36 in_40 vref 6.768908e-8
Gw1_41_36 0 sum_h_36 in_41 vref 5.379279e-8
Gw1_42_36 0 sum_h_36 in_42 vref 3.000445e-8
Gw1_43_36 0 sum_h_36 in_43 vref -8.871811e-8
Gw1_44_36 0 sum_h_36 in_44 vref -1.921634e-7
Gw1_45_36 0 sum_h_36 in_45 vref -1.926548e-7
Gw1_46_36 0 sum_h_36 in_46 vref -1.073002e-7
Gw1_47_36 0 sum_h_36 in_47 vref -1.395907e-7
Gw1_48_36 0 sum_h_36 in_48 vref -4.924616e-8
Gw1_0_37 0 sum_h_37 in_0 vref -2.276737e-8
Gw1_1_37 0 sum_h_37 in_1 vref -1.310251e-8
Gw1_2_37 0 sum_h_37 in_2 vref 1.331878e-7
Gw1_3_37 0 sum_h_37 in_3 vref -5.987469e-8
Gw1_4_37 0 sum_h_37 in_4 vref 6.640066e-8
Gw1_5_37 0 sum_h_37 in_5 vref 1.136724e-7
Gw1_6_37 0 sum_h_37 in_6 vref -7.624944e-8
Gw1_7_37 0 sum_h_37 in_7 vref -5.234171e-8
Gw1_8_37 0 sum_h_37 in_8 vref -1.725780e-7
Gw1_9_37 0 sum_h_37 in_9 vref 1.027263e-7
Gw1_10_37 0 sum_h_37 in_10 vref 8.719701e-9
Gw1_11_37 0 sum_h_37 in_11 vref 1.304312e-7
Gw1_12_37 0 sum_h_37 in_12 vref 1.606025e-7
Gw1_13_37 0 sum_h_37 in_13 vref 3.657541e-8
Gw1_14_37 0 sum_h_37 in_14 vref 2.932703e-9
Gw1_15_37 0 sum_h_37 in_15 vref -2.808528e-8
Gw1_16_37 0 sum_h_37 in_16 vref -3.462708e-8
Gw1_17_37 0 sum_h_37 in_17 vref -7.900057e-9
Gw1_18_37 0 sum_h_37 in_18 vref -1.367398e-7
Gw1_19_37 0 sum_h_37 in_19 vref -1.886888e-8
Gw1_20_37 0 sum_h_37 in_20 vref -1.235901e-7
Gw1_21_37 0 sum_h_37 in_21 vref -9.142100e-8
Gw1_22_37 0 sum_h_37 in_22 vref 4.939172e-9
Gw1_23_37 0 sum_h_37 in_23 vref -2.364893e-7
Gw1_24_37 0 sum_h_37 in_24 vref 5.221642e-8
Gw1_25_37 0 sum_h_37 in_25 vref 8.530453e-8
Gw1_26_37 0 sum_h_37 in_26 vref -1.721266e-7
Gw1_27_37 0 sum_h_37 in_27 vref -9.214414e-9
Gw1_28_37 0 sum_h_37 in_28 vref 1.201703e-7
Gw1_29_37 0 sum_h_37 in_29 vref -8.066845e-8
Gw1_30_37 0 sum_h_37 in_30 vref -3.481095e-8
Gw1_31_37 0 sum_h_37 in_31 vref -1.029321e-7
Gw1_32_37 0 sum_h_37 in_32 vref 1.205210e-7
Gw1_33_37 0 sum_h_37 in_33 vref 3.510842e-8
Gw1_34_37 0 sum_h_37 in_34 vref -2.358273e-8
Gw1_35_37 0 sum_h_37 in_35 vref -3.909902e-8
Gw1_36_37 0 sum_h_37 in_36 vref -9.500864e-8
Gw1_37_37 0 sum_h_37 in_37 vref 4.481295e-8
Gw1_38_37 0 sum_h_37 in_38 vref -9.057972e-8
Gw1_39_37 0 sum_h_37 in_39 vref 7.588081e-8
Gw1_40_37 0 sum_h_37 in_40 vref 8.501491e-9
Gw1_41_37 0 sum_h_37 in_41 vref -6.453925e-8
Gw1_42_37 0 sum_h_37 in_42 vref -7.990551e-8
Gw1_43_37 0 sum_h_37 in_43 vref -5.812488e-8
Gw1_44_37 0 sum_h_37 in_44 vref 1.403793e-7
Gw1_45_37 0 sum_h_37 in_45 vref 2.304444e-7
Gw1_46_37 0 sum_h_37 in_46 vref -8.609140e-8
Gw1_47_37 0 sum_h_37 in_47 vref -1.079885e-7
Gw1_48_37 0 sum_h_37 in_48 vref 2.085283e-9
Gw1_0_38 0 sum_h_38 in_0 vref 4.053254e-9
Gw1_1_38 0 sum_h_38 in_1 vref 9.581569e-8
Gw1_2_38 0 sum_h_38 in_2 vref 2.333340e-8
Gw1_3_38 0 sum_h_38 in_3 vref 5.996341e-8
Gw1_4_38 0 sum_h_38 in_4 vref 5.455285e-8
Gw1_5_38 0 sum_h_38 in_5 vref 1.077427e-7
Gw1_6_38 0 sum_h_38 in_6 vref -1.316702e-7
Gw1_7_38 0 sum_h_38 in_7 vref -9.943218e-8
Gw1_8_38 0 sum_h_38 in_8 vref -6.671912e-8
Gw1_9_38 0 sum_h_38 in_9 vref -8.631828e-8
Gw1_10_38 0 sum_h_38 in_10 vref 3.987541e-8
Gw1_11_38 0 sum_h_38 in_11 vref 1.227158e-7
Gw1_12_38 0 sum_h_38 in_12 vref 1.907376e-7
Gw1_13_38 0 sum_h_38 in_13 vref -7.201739e-8
Gw1_14_38 0 sum_h_38 in_14 vref 1.342773e-7
Gw1_15_38 0 sum_h_38 in_15 vref 4.618633e-8
Gw1_16_38 0 sum_h_38 in_16 vref 3.625279e-9
Gw1_17_38 0 sum_h_38 in_17 vref -1.171036e-7
Gw1_18_38 0 sum_h_38 in_18 vref -3.311498e-8
Gw1_19_38 0 sum_h_38 in_19 vref 2.374645e-7
Gw1_20_38 0 sum_h_38 in_20 vref -1.202384e-7
Gw1_21_38 0 sum_h_38 in_21 vref 1.016797e-7
Gw1_22_38 0 sum_h_38 in_22 vref 7.249540e-8
Gw1_23_38 0 sum_h_38 in_23 vref -7.839957e-8
Gw1_24_38 0 sum_h_38 in_24 vref 4.476529e-8
Gw1_25_38 0 sum_h_38 in_25 vref 7.291655e-8
Gw1_26_38 0 sum_h_38 in_26 vref 1.094634e-7
Gw1_27_38 0 sum_h_38 in_27 vref -1.254127e-7
Gw1_28_38 0 sum_h_38 in_28 vref -2.955875e-8
Gw1_29_38 0 sum_h_38 in_29 vref -1.935588e-8
Gw1_30_38 0 sum_h_38 in_30 vref -1.652297e-8
Gw1_31_38 0 sum_h_38 in_31 vref -2.953425e-8
Gw1_32_38 0 sum_h_38 in_32 vref -9.432941e-8
Gw1_33_38 0 sum_h_38 in_33 vref 3.807167e-8
Gw1_34_38 0 sum_h_38 in_34 vref -1.832325e-8
Gw1_35_38 0 sum_h_38 in_35 vref 6.047586e-8
Gw1_36_38 0 sum_h_38 in_36 vref -1.233927e-7
Gw1_37_38 0 sum_h_38 in_37 vref 3.540259e-8
Gw1_38_38 0 sum_h_38 in_38 vref -3.700226e-8
Gw1_39_38 0 sum_h_38 in_39 vref 1.491315e-9
Gw1_40_38 0 sum_h_38 in_40 vref -1.022443e-7
Gw1_41_38 0 sum_h_38 in_41 vref 1.311963e-7
Gw1_42_38 0 sum_h_38 in_42 vref 8.891667e-9
Gw1_43_38 0 sum_h_38 in_43 vref 2.032615e-7
Gw1_44_38 0 sum_h_38 in_44 vref -1.097365e-7
Gw1_45_38 0 sum_h_38 in_45 vref -1.485032e-7
Gw1_46_38 0 sum_h_38 in_46 vref 1.188587e-8
Gw1_47_38 0 sum_h_38 in_47 vref -9.029211e-8
Gw1_48_38 0 sum_h_38 in_48 vref -1.313830e-7
Gw1_0_39 0 sum_h_39 in_0 vref 7.797173e-8
Gw1_1_39 0 sum_h_39 in_1 vref 3.811532e-8
Gw1_2_39 0 sum_h_39 in_2 vref 2.901145e-8
Gw1_3_39 0 sum_h_39 in_3 vref -6.828956e-8
Gw1_4_39 0 sum_h_39 in_4 vref 4.523685e-8
Gw1_5_39 0 sum_h_39 in_5 vref -8.161615e-8
Gw1_6_39 0 sum_h_39 in_6 vref 1.126475e-7
Gw1_7_39 0 sum_h_39 in_7 vref -9.494676e-8
Gw1_8_39 0 sum_h_39 in_8 vref -4.282068e-8
Gw1_9_39 0 sum_h_39 in_9 vref -2.125779e-7
Gw1_10_39 0 sum_h_39 in_10 vref 1.143899e-7
Gw1_11_39 0 sum_h_39 in_11 vref -1.808129e-8
Gw1_12_39 0 sum_h_39 in_12 vref 6.369137e-8
Gw1_13_39 0 sum_h_39 in_13 vref 1.623030e-7
Gw1_14_39 0 sum_h_39 in_14 vref 2.936790e-8
Gw1_15_39 0 sum_h_39 in_15 vref -1.606001e-7
Gw1_16_39 0 sum_h_39 in_16 vref -4.943633e-8
Gw1_17_39 0 sum_h_39 in_17 vref 8.225114e-8
Gw1_18_39 0 sum_h_39 in_18 vref -1.204345e-7
Gw1_19_39 0 sum_h_39 in_19 vref -2.006635e-7
Gw1_20_39 0 sum_h_39 in_20 vref -7.380317e-8
Gw1_21_39 0 sum_h_39 in_21 vref 9.263436e-8
Gw1_22_39 0 sum_h_39 in_22 vref -5.398110e-8
Gw1_23_39 0 sum_h_39 in_23 vref -1.667652e-7
Gw1_24_39 0 sum_h_39 in_24 vref 1.181743e-8
Gw1_25_39 0 sum_h_39 in_25 vref 6.385738e-8
Gw1_26_39 0 sum_h_39 in_26 vref -5.487280e-8
Gw1_27_39 0 sum_h_39 in_27 vref 7.829949e-8
Gw1_28_39 0 sum_h_39 in_28 vref -3.947804e-8
Gw1_29_39 0 sum_h_39 in_29 vref -1.307754e-10
Gw1_30_39 0 sum_h_39 in_30 vref -1.473434e-7
Gw1_31_39 0 sum_h_39 in_31 vref -1.946248e-8
Gw1_32_39 0 sum_h_39 in_32 vref 1.050340e-7
Gw1_33_39 0 sum_h_39 in_33 vref -4.593847e-8
Gw1_34_39 0 sum_h_39 in_34 vref 4.203556e-8
Gw1_35_39 0 sum_h_39 in_35 vref 9.398434e-9
Gw1_36_39 0 sum_h_39 in_36 vref 1.154981e-7
Gw1_37_39 0 sum_h_39 in_37 vref 2.914887e-8
Gw1_38_39 0 sum_h_39 in_38 vref 1.655819e-7
Gw1_39_39 0 sum_h_39 in_39 vref 7.711657e-8
Gw1_40_39 0 sum_h_39 in_40 vref 1.883767e-8
Gw1_41_39 0 sum_h_39 in_41 vref -3.233286e-8
Gw1_42_39 0 sum_h_39 in_42 vref -6.615422e-8
Gw1_43_39 0 sum_h_39 in_43 vref -3.863863e-8
Gw1_44_39 0 sum_h_39 in_44 vref 1.447977e-7
Gw1_45_39 0 sum_h_39 in_45 vref 2.889817e-8
Gw1_46_39 0 sum_h_39 in_46 vref -8.343167e-8
Gw1_47_39 0 sum_h_39 in_47 vref 1.094539e-7
Gw1_48_39 0 sum_h_39 in_48 vref -1.290225e-7
Gw1_0_40 0 sum_h_40 in_0 vref 1.036159e-7
Gw1_1_40 0 sum_h_40 in_1 vref 3.943332e-8
Gw1_2_40 0 sum_h_40 in_2 vref -5.623394e-8
Gw1_3_40 0 sum_h_40 in_3 vref 8.684670e-8
Gw1_4_40 0 sum_h_40 in_4 vref -1.398921e-7
Gw1_5_40 0 sum_h_40 in_5 vref 9.141649e-8
Gw1_6_40 0 sum_h_40 in_6 vref 9.063206e-8
Gw1_7_40 0 sum_h_40 in_7 vref -3.667574e-8
Gw1_8_40 0 sum_h_40 in_8 vref -8.971517e-8
Gw1_9_40 0 sum_h_40 in_9 vref 3.856572e-9
Gw1_10_40 0 sum_h_40 in_10 vref 5.182292e-8
Gw1_11_40 0 sum_h_40 in_11 vref 5.218287e-10
Gw1_12_40 0 sum_h_40 in_12 vref 1.318405e-7
Gw1_13_40 0 sum_h_40 in_13 vref -4.453339e-8
Gw1_14_40 0 sum_h_40 in_14 vref 1.145898e-7
Gw1_15_40 0 sum_h_40 in_15 vref -8.870274e-8
Gw1_16_40 0 sum_h_40 in_16 vref 1.215416e-8
Gw1_17_40 0 sum_h_40 in_17 vref -1.050364e-7
Gw1_18_40 0 sum_h_40 in_18 vref 1.274552e-7
Gw1_19_40 0 sum_h_40 in_19 vref 1.482778e-7
Gw1_20_40 0 sum_h_40 in_20 vref 8.764381e-8
Gw1_21_40 0 sum_h_40 in_21 vref 1.121423e-8
Gw1_22_40 0 sum_h_40 in_22 vref 2.751032e-8
Gw1_23_40 0 sum_h_40 in_23 vref -8.699429e-8
Gw1_24_40 0 sum_h_40 in_24 vref -4.078838e-8
Gw1_25_40 0 sum_h_40 in_25 vref 1.619133e-9
Gw1_26_40 0 sum_h_40 in_26 vref -1.160920e-7
Gw1_27_40 0 sum_h_40 in_27 vref 2.880661e-8
Gw1_28_40 0 sum_h_40 in_28 vref 8.909925e-8
Gw1_29_40 0 sum_h_40 in_29 vref -1.736775e-9
Gw1_30_40 0 sum_h_40 in_30 vref 1.622126e-7
Gw1_31_40 0 sum_h_40 in_31 vref -8.310473e-8
Gw1_32_40 0 sum_h_40 in_32 vref -1.437242e-7
Gw1_33_40 0 sum_h_40 in_33 vref 4.760096e-9
Gw1_34_40 0 sum_h_40 in_34 vref 1.289835e-7
Gw1_35_40 0 sum_h_40 in_35 vref 1.116812e-7
Gw1_36_40 0 sum_h_40 in_36 vref 1.241834e-7
Gw1_37_40 0 sum_h_40 in_37 vref -5.315923e-8
Gw1_38_40 0 sum_h_40 in_38 vref -1.095681e-7
Gw1_39_40 0 sum_h_40 in_39 vref 1.119407e-7
Gw1_40_40 0 sum_h_40 in_40 vref -5.995932e-9
Gw1_41_40 0 sum_h_40 in_41 vref -8.615824e-8
Gw1_42_40 0 sum_h_40 in_42 vref -1.877808e-8
Gw1_43_40 0 sum_h_40 in_43 vref 1.124010e-7
Gw1_44_40 0 sum_h_40 in_44 vref -2.154499e-8
Gw1_45_40 0 sum_h_40 in_45 vref -1.153571e-7
Gw1_46_40 0 sum_h_40 in_46 vref -5.542369e-9
Gw1_47_40 0 sum_h_40 in_47 vref 1.409000e-7
Gw1_48_40 0 sum_h_40 in_48 vref -8.823806e-9
Gw1_0_41 0 sum_h_41 in_0 vref -6.625928e-8
Gw1_1_41 0 sum_h_41 in_1 vref -5.436852e-8
Gw1_2_41 0 sum_h_41 in_2 vref 8.618542e-8
Gw1_3_41 0 sum_h_41 in_3 vref 6.680257e-8
Gw1_4_41 0 sum_h_41 in_4 vref 5.374173e-8
Gw1_5_41 0 sum_h_41 in_5 vref -1.167009e-7
Gw1_6_41 0 sum_h_41 in_6 vref -9.867735e-8
Gw1_7_41 0 sum_h_41 in_7 vref 1.216803e-7
Gw1_8_41 0 sum_h_41 in_8 vref -4.209316e-8
Gw1_9_41 0 sum_h_41 in_9 vref -4.045108e-8
Gw1_10_41 0 sum_h_41 in_10 vref -8.289856e-8
Gw1_11_41 0 sum_h_41 in_11 vref 1.811159e-8
Gw1_12_41 0 sum_h_41 in_12 vref 4.330610e-8
Gw1_13_41 0 sum_h_41 in_13 vref -6.206800e-8
Gw1_14_41 0 sum_h_41 in_14 vref -3.433154e-8
Gw1_15_41 0 sum_h_41 in_15 vref -6.300875e-8
Gw1_16_41 0 sum_h_41 in_16 vref 6.263359e-8
Gw1_17_41 0 sum_h_41 in_17 vref -6.226424e-9
Gw1_18_41 0 sum_h_41 in_18 vref 1.123662e-7
Gw1_19_41 0 sum_h_41 in_19 vref -1.174385e-8
Gw1_20_41 0 sum_h_41 in_20 vref -1.770063e-7
Gw1_21_41 0 sum_h_41 in_21 vref -1.921313e-8
Gw1_22_41 0 sum_h_41 in_22 vref 7.823326e-8
Gw1_23_41 0 sum_h_41 in_23 vref -7.150356e-8
Gw1_24_41 0 sum_h_41 in_24 vref 1.472319e-8
Gw1_25_41 0 sum_h_41 in_25 vref 8.093846e-8
Gw1_26_41 0 sum_h_41 in_26 vref 1.300033e-8
Gw1_27_41 0 sum_h_41 in_27 vref 4.880281e-8
Gw1_28_41 0 sum_h_41 in_28 vref -1.666730e-8
Gw1_29_41 0 sum_h_41 in_29 vref 2.544193e-8
Gw1_30_41 0 sum_h_41 in_30 vref 1.419271e-7
Gw1_31_41 0 sum_h_41 in_31 vref 3.216892e-8
Gw1_32_41 0 sum_h_41 in_32 vref 1.170995e-7
Gw1_33_41 0 sum_h_41 in_33 vref 7.381676e-8
Gw1_34_41 0 sum_h_41 in_34 vref 7.575589e-8
Gw1_35_41 0 sum_h_41 in_35 vref 1.554710e-7
Gw1_36_41 0 sum_h_41 in_36 vref -1.046122e-7
Gw1_37_41 0 sum_h_41 in_37 vref -1.616893e-7
Gw1_38_41 0 sum_h_41 in_38 vref 1.670947e-9
Gw1_39_41 0 sum_h_41 in_39 vref -6.623367e-8
Gw1_40_41 0 sum_h_41 in_40 vref -8.060768e-8
Gw1_41_41 0 sum_h_41 in_41 vref -1.387770e-8
Gw1_42_41 0 sum_h_41 in_42 vref 6.457029e-8
Gw1_43_41 0 sum_h_41 in_43 vref 9.985474e-8
Gw1_44_41 0 sum_h_41 in_44 vref 8.273268e-8
Gw1_45_41 0 sum_h_41 in_45 vref -5.180968e-8
Gw1_46_41 0 sum_h_41 in_46 vref -9.033981e-8
Gw1_47_41 0 sum_h_41 in_47 vref 1.582833e-7
Gw1_48_41 0 sum_h_41 in_48 vref 3.783892e-10
Gw1_0_42 0 sum_h_42 in_0 vref -1.728719e-8
Gw1_1_42 0 sum_h_42 in_1 vref -4.263303e-8
Gw1_2_42 0 sum_h_42 in_2 vref 6.897671e-8
Gw1_3_42 0 sum_h_42 in_3 vref 2.245750e-7
Gw1_4_42 0 sum_h_42 in_4 vref -2.335148e-8
Gw1_5_42 0 sum_h_42 in_5 vref 1.125901e-7
Gw1_6_42 0 sum_h_42 in_6 vref 8.620198e-8
Gw1_7_42 0 sum_h_42 in_7 vref -1.073410e-7
Gw1_8_42 0 sum_h_42 in_8 vref 6.004858e-8
Gw1_9_42 0 sum_h_42 in_9 vref -3.275644e-8
Gw1_10_42 0 sum_h_42 in_10 vref 3.444756e-8
Gw1_11_42 0 sum_h_42 in_11 vref 8.776369e-8
Gw1_12_42 0 sum_h_42 in_12 vref 8.314657e-8
Gw1_13_42 0 sum_h_42 in_13 vref 1.338768e-7
Gw1_14_42 0 sum_h_42 in_14 vref -2.393962e-8
Gw1_15_42 0 sum_h_42 in_15 vref -2.116607e-8
Gw1_16_42 0 sum_h_42 in_16 vref -1.315942e-8
Gw1_17_42 0 sum_h_42 in_17 vref -6.397890e-8
Gw1_18_42 0 sum_h_42 in_18 vref 5.643123e-8
Gw1_19_42 0 sum_h_42 in_19 vref -5.459435e-8
Gw1_20_42 0 sum_h_42 in_20 vref 1.441166e-8
Gw1_21_42 0 sum_h_42 in_21 vref -7.438950e-8
Gw1_22_42 0 sum_h_42 in_22 vref 2.693627e-8
Gw1_23_42 0 sum_h_42 in_23 vref -1.595510e-7
Gw1_24_42 0 sum_h_42 in_24 vref -6.841808e-9
Gw1_25_42 0 sum_h_42 in_25 vref -2.655440e-7
Gw1_26_42 0 sum_h_42 in_26 vref -9.179534e-8
Gw1_27_42 0 sum_h_42 in_27 vref -8.977665e-8
Gw1_28_42 0 sum_h_42 in_28 vref 8.591803e-8
Gw1_29_42 0 sum_h_42 in_29 vref -1.498363e-7
Gw1_30_42 0 sum_h_42 in_30 vref 1.920184e-7
Gw1_31_42 0 sum_h_42 in_31 vref -9.783386e-8
Gw1_32_42 0 sum_h_42 in_32 vref -2.414225e-7
Gw1_33_42 0 sum_h_42 in_33 vref 1.095163e-7
Gw1_34_42 0 sum_h_42 in_34 vref -1.079934e-7
Gw1_35_42 0 sum_h_42 in_35 vref -8.081244e-8
Gw1_36_42 0 sum_h_42 in_36 vref 9.905053e-9
Gw1_37_42 0 sum_h_42 in_37 vref 1.051014e-7
Gw1_38_42 0 sum_h_42 in_38 vref 6.608843e-8
Gw1_39_42 0 sum_h_42 in_39 vref 3.326524e-8
Gw1_40_42 0 sum_h_42 in_40 vref 1.046872e-8
Gw1_41_42 0 sum_h_42 in_41 vref 1.139479e-7
Gw1_42_42 0 sum_h_42 in_42 vref -1.373091e-7
Gw1_43_42 0 sum_h_42 in_43 vref -8.372052e-8
Gw1_44_42 0 sum_h_42 in_44 vref -1.893803e-8
Gw1_45_42 0 sum_h_42 in_45 vref 9.116138e-8
Gw1_46_42 0 sum_h_42 in_46 vref 1.817744e-7
Gw1_47_42 0 sum_h_42 in_47 vref 3.583081e-9
Gw1_48_42 0 sum_h_42 in_48 vref -8.867138e-8
Gw1_0_43 0 sum_h_43 in_0 vref 1.157902e-8
Gw1_1_43 0 sum_h_43 in_1 vref -1.077532e-7
Gw1_2_43 0 sum_h_43 in_2 vref -1.267604e-7
Gw1_3_43 0 sum_h_43 in_3 vref 2.148839e-7
Gw1_4_43 0 sum_h_43 in_4 vref 1.561961e-7
Gw1_5_43 0 sum_h_43 in_5 vref 1.073826e-7
Gw1_6_43 0 sum_h_43 in_6 vref 6.224045e-8
Gw1_7_43 0 sum_h_43 in_7 vref 1.190631e-7
Gw1_8_43 0 sum_h_43 in_8 vref 5.781155e-8
Gw1_9_43 0 sum_h_43 in_9 vref -9.347409e-8
Gw1_10_43 0 sum_h_43 in_10 vref 2.249183e-7
Gw1_11_43 0 sum_h_43 in_11 vref -3.884385e-9
Gw1_12_43 0 sum_h_43 in_12 vref 3.329705e-8
Gw1_13_43 0 sum_h_43 in_13 vref -2.598988e-8
Gw1_14_43 0 sum_h_43 in_14 vref -4.985904e-8
Gw1_15_43 0 sum_h_43 in_15 vref -1.123693e-7
Gw1_16_43 0 sum_h_43 in_16 vref 2.139103e-8
Gw1_17_43 0 sum_h_43 in_17 vref 1.605722e-7
Gw1_18_43 0 sum_h_43 in_18 vref 4.172502e-9
Gw1_19_43 0 sum_h_43 in_19 vref -5.236060e-8
Gw1_20_43 0 sum_h_43 in_20 vref 6.296031e-8
Gw1_21_43 0 sum_h_43 in_21 vref 3.796597e-10
Gw1_22_43 0 sum_h_43 in_22 vref 2.385821e-8
Gw1_23_43 0 sum_h_43 in_23 vref 2.088001e-7
Gw1_24_43 0 sum_h_43 in_24 vref -2.090164e-7
Gw1_25_43 0 sum_h_43 in_25 vref -5.661661e-8
Gw1_26_43 0 sum_h_43 in_26 vref 2.379942e-8
Gw1_27_43 0 sum_h_43 in_27 vref 1.105529e-7
Gw1_28_43 0 sum_h_43 in_28 vref 8.104418e-8
Gw1_29_43 0 sum_h_43 in_29 vref 6.154843e-8
Gw1_30_43 0 sum_h_43 in_30 vref 7.141595e-8
Gw1_31_43 0 sum_h_43 in_31 vref -9.623207e-8
Gw1_32_43 0 sum_h_43 in_32 vref -6.999979e-8
Gw1_33_43 0 sum_h_43 in_33 vref 3.913198e-8
Gw1_34_43 0 sum_h_43 in_34 vref -2.209197e-8
Gw1_35_43 0 sum_h_43 in_35 vref 8.013371e-8
Gw1_36_43 0 sum_h_43 in_36 vref -1.288882e-7
Gw1_37_43 0 sum_h_43 in_37 vref 3.172905e-8
Gw1_38_43 0 sum_h_43 in_38 vref 3.227099e-8
Gw1_39_43 0 sum_h_43 in_39 vref -5.345765e-8
Gw1_40_43 0 sum_h_43 in_40 vref -8.672539e-8
Gw1_41_43 0 sum_h_43 in_41 vref 3.380651e-8
Gw1_42_43 0 sum_h_43 in_42 vref -1.343437e-7
Gw1_43_43 0 sum_h_43 in_43 vref -1.300926e-7
Gw1_44_43 0 sum_h_43 in_44 vref -1.124688e-7
Gw1_45_43 0 sum_h_43 in_45 vref -7.015854e-8
Gw1_46_43 0 sum_h_43 in_46 vref -5.805888e-8
Gw1_47_43 0 sum_h_43 in_47 vref -1.305955e-7
Gw1_48_43 0 sum_h_43 in_48 vref 4.628975e-8
Gw1_0_44 0 sum_h_44 in_0 vref -1.238855e-7
Gw1_1_44 0 sum_h_44 in_1 vref 1.618336e-8
Gw1_2_44 0 sum_h_44 in_2 vref 1.987338e-8
Gw1_3_44 0 sum_h_44 in_3 vref 5.658211e-8
Gw1_4_44 0 sum_h_44 in_4 vref -3.299989e-8
Gw1_5_44 0 sum_h_44 in_5 vref -1.159857e-7
Gw1_6_44 0 sum_h_44 in_6 vref 3.085016e-8
Gw1_7_44 0 sum_h_44 in_7 vref 1.091952e-7
Gw1_8_44 0 sum_h_44 in_8 vref -8.826424e-8
Gw1_9_44 0 sum_h_44 in_9 vref 9.083781e-8
Gw1_10_44 0 sum_h_44 in_10 vref 1.101487e-7
Gw1_11_44 0 sum_h_44 in_11 vref 8.950729e-8
Gw1_12_44 0 sum_h_44 in_12 vref -1.502680e-8
Gw1_13_44 0 sum_h_44 in_13 vref -1.738485e-8
Gw1_14_44 0 sum_h_44 in_14 vref -1.097289e-7
Gw1_15_44 0 sum_h_44 in_15 vref -4.070780e-8
Gw1_16_44 0 sum_h_44 in_16 vref 6.633298e-8
Gw1_17_44 0 sum_h_44 in_17 vref 1.827366e-8
Gw1_18_44 0 sum_h_44 in_18 vref 1.650600e-7
Gw1_19_44 0 sum_h_44 in_19 vref 1.809158e-8
Gw1_20_44 0 sum_h_44 in_20 vref -6.699798e-8
Gw1_21_44 0 sum_h_44 in_21 vref -1.349362e-7
Gw1_22_44 0 sum_h_44 in_22 vref 2.993436e-8
Gw1_23_44 0 sum_h_44 in_23 vref -7.838122e-8
Gw1_24_44 0 sum_h_44 in_24 vref 8.534903e-8
Gw1_25_44 0 sum_h_44 in_25 vref 5.783491e-8
Gw1_26_44 0 sum_h_44 in_26 vref 1.242046e-7
Gw1_27_44 0 sum_h_44 in_27 vref -1.313727e-7
Gw1_28_44 0 sum_h_44 in_28 vref 1.112045e-7
Gw1_29_44 0 sum_h_44 in_29 vref -1.447642e-7
Gw1_30_44 0 sum_h_44 in_30 vref 4.477364e-8
Gw1_31_44 0 sum_h_44 in_31 vref 1.037218e-7
Gw1_32_44 0 sum_h_44 in_32 vref -1.739785e-7
Gw1_33_44 0 sum_h_44 in_33 vref -7.216458e-8
Gw1_34_44 0 sum_h_44 in_34 vref -5.733445e-8
Gw1_35_44 0 sum_h_44 in_35 vref 3.232874e-8
Gw1_36_44 0 sum_h_44 in_36 vref -1.051470e-7
Gw1_37_44 0 sum_h_44 in_37 vref -1.320570e-7
Gw1_38_44 0 sum_h_44 in_38 vref -1.396018e-7
Gw1_39_44 0 sum_h_44 in_39 vref -3.202680e-8
Gw1_40_44 0 sum_h_44 in_40 vref 3.259404e-8
Gw1_41_44 0 sum_h_44 in_41 vref -9.476715e-8
Gw1_42_44 0 sum_h_44 in_42 vref -8.811384e-8
Gw1_43_44 0 sum_h_44 in_43 vref 2.069029e-8
Gw1_44_44 0 sum_h_44 in_44 vref 8.409139e-8
Gw1_45_44 0 sum_h_44 in_45 vref 6.288665e-8
Gw1_46_44 0 sum_h_44 in_46 vref -2.395482e-9
Gw1_47_44 0 sum_h_44 in_47 vref -6.983810e-8
Gw1_48_44 0 sum_h_44 in_48 vref -1.652909e-8
Gw1_0_45 0 sum_h_45 in_0 vref -2.638003e-8
Gw1_1_45 0 sum_h_45 in_1 vref -8.338543e-8
Gw1_2_45 0 sum_h_45 in_2 vref 1.262461e-7
Gw1_3_45 0 sum_h_45 in_3 vref 2.322474e-8
Gw1_4_45 0 sum_h_45 in_4 vref -1.293992e-7
Gw1_5_45 0 sum_h_45 in_5 vref 7.257237e-8
Gw1_6_45 0 sum_h_45 in_6 vref -7.920734e-8
Gw1_7_45 0 sum_h_45 in_7 vref -3.336579e-8
Gw1_8_45 0 sum_h_45 in_8 vref -9.952740e-9
Gw1_9_45 0 sum_h_45 in_9 vref 8.947049e-8
Gw1_10_45 0 sum_h_45 in_10 vref -2.090288e-7
Gw1_11_45 0 sum_h_45 in_11 vref 1.031291e-7
Gw1_12_45 0 sum_h_45 in_12 vref 8.550076e-8
Gw1_13_45 0 sum_h_45 in_13 vref 6.879861e-8
Gw1_14_45 0 sum_h_45 in_14 vref 1.062129e-7
Gw1_15_45 0 sum_h_45 in_15 vref 1.299543e-7
Gw1_16_45 0 sum_h_45 in_16 vref 8.154695e-8
Gw1_17_45 0 sum_h_45 in_17 vref -1.401114e-7
Gw1_18_45 0 sum_h_45 in_18 vref 1.072460e-7
Gw1_19_45 0 sum_h_45 in_19 vref -8.303667e-9
Gw1_20_45 0 sum_h_45 in_20 vref -1.245857e-7
Gw1_21_45 0 sum_h_45 in_21 vref 8.839694e-8
Gw1_22_45 0 sum_h_45 in_22 vref -2.966819e-7
Gw1_23_45 0 sum_h_45 in_23 vref -1.803320e-7
Gw1_24_45 0 sum_h_45 in_24 vref 1.220437e-7
Gw1_25_45 0 sum_h_45 in_25 vref 2.226975e-8
Gw1_26_45 0 sum_h_45 in_26 vref 1.748354e-7
Gw1_27_45 0 sum_h_45 in_27 vref -1.450760e-8
Gw1_28_45 0 sum_h_45 in_28 vref -9.058733e-8
Gw1_29_45 0 sum_h_45 in_29 vref -1.515467e-7
Gw1_30_45 0 sum_h_45 in_30 vref 1.287011e-7
Gw1_31_45 0 sum_h_45 in_31 vref 3.097099e-8
Gw1_32_45 0 sum_h_45 in_32 vref -5.245683e-8
Gw1_33_45 0 sum_h_45 in_33 vref -1.096449e-7
Gw1_34_45 0 sum_h_45 in_34 vref 1.336535e-7
Gw1_35_45 0 sum_h_45 in_35 vref 2.294875e-8
Gw1_36_45 0 sum_h_45 in_36 vref 8.959520e-8
Gw1_37_45 0 sum_h_45 in_37 vref -9.837881e-8
Gw1_38_45 0 sum_h_45 in_38 vref -5.483637e-8
Gw1_39_45 0 sum_h_45 in_39 vref 1.113746e-7
Gw1_40_45 0 sum_h_45 in_40 vref 5.812342e-8
Gw1_41_45 0 sum_h_45 in_41 vref -4.834268e-8
Gw1_42_45 0 sum_h_45 in_42 vref 1.141691e-8
Gw1_43_45 0 sum_h_45 in_43 vref -1.788395e-8
Gw1_44_45 0 sum_h_45 in_44 vref 2.194817e-8
Gw1_45_45 0 sum_h_45 in_45 vref 1.064221e-7
Gw1_46_45 0 sum_h_45 in_46 vref 4.248855e-9
Gw1_47_45 0 sum_h_45 in_47 vref -6.352205e-8
Gw1_48_45 0 sum_h_45 in_48 vref -8.899838e-8
Gw1_0_46 0 sum_h_46 in_0 vref 3.626995e-8
Gw1_1_46 0 sum_h_46 in_1 vref 2.458664e-8
Gw1_2_46 0 sum_h_46 in_2 vref -2.704443e-8
Gw1_3_46 0 sum_h_46 in_3 vref -4.663733e-8
Gw1_4_46 0 sum_h_46 in_4 vref -1.159744e-7
Gw1_5_46 0 sum_h_46 in_5 vref -6.325327e-8
Gw1_6_46 0 sum_h_46 in_6 vref -4.568008e-9
Gw1_7_46 0 sum_h_46 in_7 vref 1.112938e-7
Gw1_8_46 0 sum_h_46 in_8 vref 1.584320e-7
Gw1_9_46 0 sum_h_46 in_9 vref 1.300709e-7
Gw1_10_46 0 sum_h_46 in_10 vref -8.932377e-8
Gw1_11_46 0 sum_h_46 in_11 vref -2.863545e-7
Gw1_12_46 0 sum_h_46 in_12 vref -1.760095e-7
Gw1_13_46 0 sum_h_46 in_13 vref -8.343525e-8
Gw1_14_46 0 sum_h_46 in_14 vref 5.963714e-8
Gw1_15_46 0 sum_h_46 in_15 vref 3.256388e-9
Gw1_16_46 0 sum_h_46 in_16 vref -5.440523e-8
Gw1_17_46 0 sum_h_46 in_17 vref 9.638129e-8
Gw1_18_46 0 sum_h_46 in_18 vref 5.546897e-8
Gw1_19_46 0 sum_h_46 in_19 vref 6.113348e-9
Gw1_20_46 0 sum_h_46 in_20 vref 1.039436e-8
Gw1_21_46 0 sum_h_46 in_21 vref 4.466764e-8
Gw1_22_46 0 sum_h_46 in_22 vref -2.536647e-8
Gw1_23_46 0 sum_h_46 in_23 vref -8.341911e-9
Gw1_24_46 0 sum_h_46 in_24 vref -1.466978e-7
Gw1_25_46 0 sum_h_46 in_25 vref 1.016355e-7
Gw1_26_46 0 sum_h_46 in_26 vref 1.136121e-7
Gw1_27_46 0 sum_h_46 in_27 vref 1.097446e-7
Gw1_28_46 0 sum_h_46 in_28 vref 5.303615e-8
Gw1_29_46 0 sum_h_46 in_29 vref 8.723836e-8
Gw1_30_46 0 sum_h_46 in_30 vref -1.582770e-7
Gw1_31_46 0 sum_h_46 in_31 vref 6.595156e-8
Gw1_32_46 0 sum_h_46 in_32 vref -9.854302e-8
Gw1_33_46 0 sum_h_46 in_33 vref 9.298605e-8
Gw1_34_46 0 sum_h_46 in_34 vref -1.424924e-8
Gw1_35_46 0 sum_h_46 in_35 vref 9.464826e-8
Gw1_36_46 0 sum_h_46 in_36 vref 5.669291e-8
Gw1_37_46 0 sum_h_46 in_37 vref 6.557590e-8
Gw1_38_46 0 sum_h_46 in_38 vref -1.741705e-8
Gw1_39_46 0 sum_h_46 in_39 vref 2.204545e-8
Gw1_40_46 0 sum_h_46 in_40 vref -2.024303e-7
Gw1_41_46 0 sum_h_46 in_41 vref -1.079749e-7
Gw1_42_46 0 sum_h_46 in_42 vref 8.051349e-8
Gw1_43_46 0 sum_h_46 in_43 vref 4.017682e-8
Gw1_44_46 0 sum_h_46 in_44 vref -1.643466e-7
Gw1_45_46 0 sum_h_46 in_45 vref -7.322883e-8
Gw1_46_46 0 sum_h_46 in_46 vref -1.189455e-7
Gw1_47_46 0 sum_h_46 in_47 vref -1.767231e-7
Gw1_48_46 0 sum_h_46 in_48 vref 5.370542e-8
Gw1_0_47 0 sum_h_47 in_0 vref 5.557063e-8
Gw1_1_47 0 sum_h_47 in_1 vref -9.655427e-8
Gw1_2_47 0 sum_h_47 in_2 vref 1.121071e-7
Gw1_3_47 0 sum_h_47 in_3 vref -7.103461e-8
Gw1_4_47 0 sum_h_47 in_4 vref 1.098318e-7
Gw1_5_47 0 sum_h_47 in_5 vref -4.143043e-8
Gw1_6_47 0 sum_h_47 in_6 vref 6.901776e-8
Gw1_7_47 0 sum_h_47 in_7 vref -2.960189e-8
Gw1_8_47 0 sum_h_47 in_8 vref 4.891404e-8
Gw1_9_47 0 sum_h_47 in_9 vref 7.562133e-9
Gw1_10_47 0 sum_h_47 in_10 vref -3.614715e-9
Gw1_11_47 0 sum_h_47 in_11 vref -3.794764e-8
Gw1_12_47 0 sum_h_47 in_12 vref 1.652598e-9
Gw1_13_47 0 sum_h_47 in_13 vref 1.006465e-7
Gw1_14_47 0 sum_h_47 in_14 vref -4.633725e-8
Gw1_15_47 0 sum_h_47 in_15 vref -1.911889e-7
Gw1_16_47 0 sum_h_47 in_16 vref 6.921754e-9
Gw1_17_47 0 sum_h_47 in_17 vref -5.322035e-8
Gw1_18_47 0 sum_h_47 in_18 vref 4.365821e-8
Gw1_19_47 0 sum_h_47 in_19 vref 3.340576e-8
Gw1_20_47 0 sum_h_47 in_20 vref 5.729727e-8
Gw1_21_47 0 sum_h_47 in_21 vref 1.215900e-7
Gw1_22_47 0 sum_h_47 in_22 vref 8.279980e-8
Gw1_23_47 0 sum_h_47 in_23 vref 2.724772e-9
Gw1_24_47 0 sum_h_47 in_24 vref 1.702750e-7
Gw1_25_47 0 sum_h_47 in_25 vref -1.256452e-8
Gw1_26_47 0 sum_h_47 in_26 vref -5.339945e-8
Gw1_27_47 0 sum_h_47 in_27 vref 1.273105e-7
Gw1_28_47 0 sum_h_47 in_28 vref -7.290043e-8
Gw1_29_47 0 sum_h_47 in_29 vref -1.700329e-7
Gw1_30_47 0 sum_h_47 in_30 vref -4.753912e-8
Gw1_31_47 0 sum_h_47 in_31 vref 4.887660e-8
Gw1_32_47 0 sum_h_47 in_32 vref -1.658017e-7
Gw1_33_47 0 sum_h_47 in_33 vref -4.686915e-9
Gw1_34_47 0 sum_h_47 in_34 vref -9.215484e-8
Gw1_35_47 0 sum_h_47 in_35 vref -6.471486e-9
Gw1_36_47 0 sum_h_47 in_36 vref -5.748869e-8
Gw1_37_47 0 sum_h_47 in_37 vref 1.657974e-7
Gw1_38_47 0 sum_h_47 in_38 vref -3.471942e-7
Gw1_39_47 0 sum_h_47 in_39 vref -1.835061e-7
Gw1_40_47 0 sum_h_47 in_40 vref 6.747325e-8
Gw1_41_47 0 sum_h_47 in_41 vref 1.409831e-7
Gw1_42_47 0 sum_h_47 in_42 vref 2.135082e-8
Gw1_43_47 0 sum_h_47 in_43 vref 2.437634e-8
Gw1_44_47 0 sum_h_47 in_44 vref 5.931629e-8
Gw1_45_47 0 sum_h_47 in_45 vref -1.275361e-8
Gw1_46_47 0 sum_h_47 in_46 vref 5.252772e-8
Gw1_47_47 0 sum_h_47 in_47 vref 9.347316e-8
Gw1_48_47 0 sum_h_47 in_48 vref -7.814105e-8
Gw1_0_48 0 sum_h_48 in_0 vref 9.477876e-8
Gw1_1_48 0 sum_h_48 in_1 vref 3.277517e-8
Gw1_2_48 0 sum_h_48 in_2 vref 1.402463e-7
Gw1_3_48 0 sum_h_48 in_3 vref 3.940460e-8
Gw1_4_48 0 sum_h_48 in_4 vref -1.067890e-7
Gw1_5_48 0 sum_h_48 in_5 vref -6.434405e-8
Gw1_6_48 0 sum_h_48 in_6 vref 1.441599e-7
Gw1_7_48 0 sum_h_48 in_7 vref 1.273583e-7
Gw1_8_48 0 sum_h_48 in_8 vref 1.864259e-7
Gw1_9_48 0 sum_h_48 in_9 vref 2.069179e-8
Gw1_10_48 0 sum_h_48 in_10 vref -1.881980e-7
Gw1_11_48 0 sum_h_48 in_11 vref 1.190793e-7
Gw1_12_48 0 sum_h_48 in_12 vref -1.398343e-7
Gw1_13_48 0 sum_h_48 in_13 vref -1.172245e-7
Gw1_14_48 0 sum_h_48 in_14 vref -4.566916e-8
Gw1_15_48 0 sum_h_48 in_15 vref -2.407347e-8
Gw1_16_48 0 sum_h_48 in_16 vref 1.426149e-7
Gw1_17_48 0 sum_h_48 in_17 vref 3.888892e-8
Gw1_18_48 0 sum_h_48 in_18 vref -5.157339e-8
Gw1_19_48 0 sum_h_48 in_19 vref -1.568241e-7
Gw1_20_48 0 sum_h_48 in_20 vref -1.180122e-7
Gw1_21_48 0 sum_h_48 in_21 vref -2.725924e-8
Gw1_22_48 0 sum_h_48 in_22 vref 7.116353e-8
Gw1_23_48 0 sum_h_48 in_23 vref -6.930909e-8
Gw1_24_48 0 sum_h_48 in_24 vref 5.271377e-8
Gw1_25_48 0 sum_h_48 in_25 vref 6.018006e-8
Gw1_26_48 0 sum_h_48 in_26 vref 1.487896e-7
Gw1_27_48 0 sum_h_48 in_27 vref -6.756638e-8
Gw1_28_48 0 sum_h_48 in_28 vref 1.101720e-7
Gw1_29_48 0 sum_h_48 in_29 vref 9.071409e-9
Gw1_30_48 0 sum_h_48 in_30 vref -2.771724e-7
Gw1_31_48 0 sum_h_48 in_31 vref -4.809411e-8
Gw1_32_48 0 sum_h_48 in_32 vref -1.111197e-7
Gw1_33_48 0 sum_h_48 in_33 vref -1.083746e-7
Gw1_34_48 0 sum_h_48 in_34 vref -6.308348e-8
Gw1_35_48 0 sum_h_48 in_35 vref -7.610267e-8
Gw1_36_48 0 sum_h_48 in_36 vref -5.382092e-8
Gw1_37_48 0 sum_h_48 in_37 vref -1.501247e-7
Gw1_38_48 0 sum_h_48 in_38 vref 1.710673e-8
Gw1_39_48 0 sum_h_48 in_39 vref 6.022213e-8
Gw1_40_48 0 sum_h_48 in_40 vref -1.524377e-7
Gw1_41_48 0 sum_h_48 in_41 vref 2.778762e-8
Gw1_42_48 0 sum_h_48 in_42 vref 5.695982e-8
Gw1_43_48 0 sum_h_48 in_43 vref -2.071120e-8
Gw1_44_48 0 sum_h_48 in_44 vref -1.990128e-7
Gw1_45_48 0 sum_h_48 in_45 vref -2.104017e-8
Gw1_46_48 0 sum_h_48 in_46 vref 1.818726e-8
Gw1_47_48 0 sum_h_48 in_47 vref 1.253854e-7
Gw1_48_48 0 sum_h_48 in_48 vref 5.637908e-8
Gw1_0_49 0 sum_h_49 in_0 vref -5.812044e-8
Gw1_1_49 0 sum_h_49 in_1 vref 8.199473e-8
Gw1_2_49 0 sum_h_49 in_2 vref 1.055627e-7
Gw1_3_49 0 sum_h_49 in_3 vref 1.946785e-8
Gw1_4_49 0 sum_h_49 in_4 vref -1.500088e-7
Gw1_5_49 0 sum_h_49 in_5 vref -1.034071e-7
Gw1_6_49 0 sum_h_49 in_6 vref 4.778504e-8
Gw1_7_49 0 sum_h_49 in_7 vref -1.121270e-7
Gw1_8_49 0 sum_h_49 in_8 vref -1.622299e-7
Gw1_9_49 0 sum_h_49 in_9 vref -2.031052e-7
Gw1_10_49 0 sum_h_49 in_10 vref 9.146517e-9
Gw1_11_49 0 sum_h_49 in_11 vref -7.224993e-8
Gw1_12_49 0 sum_h_49 in_12 vref 6.892828e-8
Gw1_13_49 0 sum_h_49 in_13 vref 1.207286e-7
Gw1_14_49 0 sum_h_49 in_14 vref -1.065972e-7
Gw1_15_49 0 sum_h_49 in_15 vref -2.046551e-7
Gw1_16_49 0 sum_h_49 in_16 vref -5.521115e-9
Gw1_17_49 0 sum_h_49 in_17 vref -3.723465e-8
Gw1_18_49 0 sum_h_49 in_18 vref 6.055721e-9
Gw1_19_49 0 sum_h_49 in_19 vref -4.320316e-8
Gw1_20_49 0 sum_h_49 in_20 vref -1.047789e-7
Gw1_21_49 0 sum_h_49 in_21 vref 9.842869e-8
Gw1_22_49 0 sum_h_49 in_22 vref -1.714363e-8
Gw1_23_49 0 sum_h_49 in_23 vref 1.834536e-7
Gw1_24_49 0 sum_h_49 in_24 vref 1.437566e-8
Gw1_25_49 0 sum_h_49 in_25 vref 4.011666e-8
Gw1_26_49 0 sum_h_49 in_26 vref 1.176194e-7
Gw1_27_49 0 sum_h_49 in_27 vref -5.885667e-8
Gw1_28_49 0 sum_h_49 in_28 vref 5.896455e-8
Gw1_29_49 0 sum_h_49 in_29 vref -5.636491e-8
Gw1_30_49 0 sum_h_49 in_30 vref 5.201103e-8
Gw1_31_49 0 sum_h_49 in_31 vref 4.900899e-9
Gw1_32_49 0 sum_h_49 in_32 vref 2.704820e-8
Gw1_33_49 0 sum_h_49 in_33 vref -5.322776e-8
Gw1_34_49 0 sum_h_49 in_34 vref 4.748732e-8
Gw1_35_49 0 sum_h_49 in_35 vref -1.117768e-7
Gw1_36_49 0 sum_h_49 in_36 vref 2.168572e-8
Gw1_37_49 0 sum_h_49 in_37 vref 9.499134e-9
Gw1_38_49 0 sum_h_49 in_38 vref 6.109009e-8
Gw1_39_49 0 sum_h_49 in_39 vref -2.348072e-8
Gw1_40_49 0 sum_h_49 in_40 vref -7.361856e-8
Gw1_41_49 0 sum_h_49 in_41 vref -4.459718e-8
Gw1_42_49 0 sum_h_49 in_42 vref -7.963857e-8
Gw1_43_49 0 sum_h_49 in_43 vref 6.609221e-8
Gw1_44_49 0 sum_h_49 in_44 vref 5.997132e-9
Gw1_45_49 0 sum_h_49 in_45 vref -4.521177e-8
Gw1_46_49 0 sum_h_49 in_46 vref -8.062063e-10
Gw1_47_49 0 sum_h_49 in_47 vref -8.015892e-8
Gw1_48_49 0 sum_h_49 in_48 vref -1.255069e-7
Gw1_0_50 0 sum_h_50 in_0 vref 8.208921e-8
Gw1_1_50 0 sum_h_50 in_1 vref 5.522332e-8
Gw1_2_50 0 sum_h_50 in_2 vref 1.475895e-7
Gw1_3_50 0 sum_h_50 in_3 vref 2.267536e-7
Gw1_4_50 0 sum_h_50 in_4 vref 1.734172e-7
Gw1_5_50 0 sum_h_50 in_5 vref -5.236644e-9
Gw1_6_50 0 sum_h_50 in_6 vref -5.854130e-9
Gw1_7_50 0 sum_h_50 in_7 vref -5.858685e-8
Gw1_8_50 0 sum_h_50 in_8 vref -5.537034e-8
Gw1_9_50 0 sum_h_50 in_9 vref -2.552989e-8
Gw1_10_50 0 sum_h_50 in_10 vref 3.729047e-8
Gw1_11_50 0 sum_h_50 in_11 vref 5.153466e-9
Gw1_12_50 0 sum_h_50 in_12 vref -5.505060e-8
Gw1_13_50 0 sum_h_50 in_13 vref -1.665914e-8
Gw1_14_50 0 sum_h_50 in_14 vref -8.817639e-9
Gw1_15_50 0 sum_h_50 in_15 vref -1.505767e-7
Gw1_16_50 0 sum_h_50 in_16 vref -1.820098e-7
Gw1_17_50 0 sum_h_50 in_17 vref 1.791761e-8
Gw1_18_50 0 sum_h_50 in_18 vref -1.318246e-7
Gw1_19_50 0 sum_h_50 in_19 vref -1.213446e-7
Gw1_20_50 0 sum_h_50 in_20 vref 2.945207e-8
Gw1_21_50 0 sum_h_50 in_21 vref 8.830834e-8
Gw1_22_50 0 sum_h_50 in_22 vref -8.364709e-8
Gw1_23_50 0 sum_h_50 in_23 vref 5.890648e-8
Gw1_24_50 0 sum_h_50 in_24 vref -3.574688e-9
Gw1_25_50 0 sum_h_50 in_25 vref 5.178514e-8
Gw1_26_50 0 sum_h_50 in_26 vref -6.132883e-8
Gw1_27_50 0 sum_h_50 in_27 vref 1.697482e-8
Gw1_28_50 0 sum_h_50 in_28 vref 1.141949e-7
Gw1_29_50 0 sum_h_50 in_29 vref -1.698223e-7
Gw1_30_50 0 sum_h_50 in_30 vref 7.961855e-8
Gw1_31_50 0 sum_h_50 in_31 vref 4.037500e-8
Gw1_32_50 0 sum_h_50 in_32 vref -2.322495e-8
Gw1_33_50 0 sum_h_50 in_33 vref -8.436108e-8
Gw1_34_50 0 sum_h_50 in_34 vref -1.058495e-7
Gw1_35_50 0 sum_h_50 in_35 vref -6.844714e-8
Gw1_36_50 0 sum_h_50 in_36 vref -3.979733e-8
Gw1_37_50 0 sum_h_50 in_37 vref 9.390059e-8
Gw1_38_50 0 sum_h_50 in_38 vref 1.039115e-7
Gw1_39_50 0 sum_h_50 in_39 vref 7.820768e-8
Gw1_40_50 0 sum_h_50 in_40 vref 1.012707e-7
Gw1_41_50 0 sum_h_50 in_41 vref 1.464573e-7
Gw1_42_50 0 sum_h_50 in_42 vref 1.089696e-7
Gw1_43_50 0 sum_h_50 in_43 vref -1.068132e-7
Gw1_44_50 0 sum_h_50 in_44 vref -2.444326e-8
Gw1_45_50 0 sum_h_50 in_45 vref -4.008459e-9
Gw1_46_50 0 sum_h_50 in_46 vref 4.566167e-8
Gw1_47_50 0 sum_h_50 in_47 vref 1.007986e-7
Gw1_48_50 0 sum_h_50 in_48 vref -4.847342e-8
Gw1_0_51 0 sum_h_51 in_0 vref -3.768806e-8
Gw1_1_51 0 sum_h_51 in_1 vref 8.952923e-8
Gw1_2_51 0 sum_h_51 in_2 vref 1.788291e-7
Gw1_3_51 0 sum_h_51 in_3 vref -1.063905e-7
Gw1_4_51 0 sum_h_51 in_4 vref -1.218038e-7
Gw1_5_51 0 sum_h_51 in_5 vref 2.192297e-8
Gw1_6_51 0 sum_h_51 in_6 vref -1.394569e-7
Gw1_7_51 0 sum_h_51 in_7 vref -1.145361e-8
Gw1_8_51 0 sum_h_51 in_8 vref 3.071615e-8
Gw1_9_51 0 sum_h_51 in_9 vref -6.284418e-8
Gw1_10_51 0 sum_h_51 in_10 vref -1.098247e-7
Gw1_11_51 0 sum_h_51 in_11 vref -1.953191e-7
Gw1_12_51 0 sum_h_51 in_12 vref -1.607118e-7
Gw1_13_51 0 sum_h_51 in_13 vref 1.009340e-7
Gw1_14_51 0 sum_h_51 in_14 vref 4.973234e-8
Gw1_15_51 0 sum_h_51 in_15 vref -3.111563e-8
Gw1_16_51 0 sum_h_51 in_16 vref 3.775836e-8
Gw1_17_51 0 sum_h_51 in_17 vref 6.493309e-8
Gw1_18_51 0 sum_h_51 in_18 vref 2.489060e-7
Gw1_19_51 0 sum_h_51 in_19 vref 2.074856e-7
Gw1_20_51 0 sum_h_51 in_20 vref 1.361282e-7
Gw1_21_51 0 sum_h_51 in_21 vref 1.271467e-7
Gw1_22_51 0 sum_h_51 in_22 vref -7.019663e-8
Gw1_23_51 0 sum_h_51 in_23 vref 7.203450e-9
Gw1_24_51 0 sum_h_51 in_24 vref -2.877640e-9
Gw1_25_51 0 sum_h_51 in_25 vref -2.520500e-7
Gw1_26_51 0 sum_h_51 in_26 vref 3.367373e-9
Gw1_27_51 0 sum_h_51 in_27 vref -1.096136e-7
Gw1_28_51 0 sum_h_51 in_28 vref 4.976710e-8
Gw1_29_51 0 sum_h_51 in_29 vref 6.349528e-8
Gw1_30_51 0 sum_h_51 in_30 vref -1.380815e-8
Gw1_31_51 0 sum_h_51 in_31 vref -1.715967e-8
Gw1_32_51 0 sum_h_51 in_32 vref 1.473028e-7
Gw1_33_51 0 sum_h_51 in_33 vref -2.077147e-7
Gw1_34_51 0 sum_h_51 in_34 vref 1.521182e-8
Gw1_35_51 0 sum_h_51 in_35 vref -5.564567e-8
Gw1_36_51 0 sum_h_51 in_36 vref -7.188537e-8
Gw1_37_51 0 sum_h_51 in_37 vref 8.299609e-9
Gw1_38_51 0 sum_h_51 in_38 vref 1.640502e-8
Gw1_39_51 0 sum_h_51 in_39 vref -3.505616e-8
Gw1_40_51 0 sum_h_51 in_40 vref 1.148202e-8
Gw1_41_51 0 sum_h_51 in_41 vref -3.192253e-8
Gw1_42_51 0 sum_h_51 in_42 vref -4.035977e-8
Gw1_43_51 0 sum_h_51 in_43 vref -1.677209e-7
Gw1_44_51 0 sum_h_51 in_44 vref -1.065457e-7
Gw1_45_51 0 sum_h_51 in_45 vref -5.547591e-8
Gw1_46_51 0 sum_h_51 in_46 vref -6.329735e-8
Gw1_47_51 0 sum_h_51 in_47 vref 7.347557e-8
Gw1_48_51 0 sum_h_51 in_48 vref 8.132333e-8
Gw1_0_52 0 sum_h_52 in_0 vref 1.150194e-8
Gw1_1_52 0 sum_h_52 in_1 vref -4.193744e-8
Gw1_2_52 0 sum_h_52 in_2 vref -1.052786e-7
Gw1_3_52 0 sum_h_52 in_3 vref -1.995553e-8
Gw1_4_52 0 sum_h_52 in_4 vref -1.452386e-7
Gw1_5_52 0 sum_h_52 in_5 vref -4.891125e-8
Gw1_6_52 0 sum_h_52 in_6 vref -2.404546e-8
Gw1_7_52 0 sum_h_52 in_7 vref 1.350141e-7
Gw1_8_52 0 sum_h_52 in_8 vref -3.714850e-8
Gw1_9_52 0 sum_h_52 in_9 vref -9.228332e-8
Gw1_10_52 0 sum_h_52 in_10 vref 3.059479e-8
Gw1_11_52 0 sum_h_52 in_11 vref -1.309328e-7
Gw1_12_52 0 sum_h_52 in_12 vref 1.114931e-8
Gw1_13_52 0 sum_h_52 in_13 vref 3.569173e-8
Gw1_14_52 0 sum_h_52 in_14 vref 1.120640e-7
Gw1_15_52 0 sum_h_52 in_15 vref -8.674564e-8
Gw1_16_52 0 sum_h_52 in_16 vref 2.160037e-9
Gw1_17_52 0 sum_h_52 in_17 vref -8.086878e-9
Gw1_18_52 0 sum_h_52 in_18 vref 8.213647e-8
Gw1_19_52 0 sum_h_52 in_19 vref -9.988932e-8
Gw1_20_52 0 sum_h_52 in_20 vref 1.228942e-7
Gw1_21_52 0 sum_h_52 in_21 vref 1.200306e-7
Gw1_22_52 0 sum_h_52 in_22 vref -1.837831e-8
Gw1_23_52 0 sum_h_52 in_23 vref 4.354096e-8
Gw1_24_52 0 sum_h_52 in_24 vref -1.341258e-7
Gw1_25_52 0 sum_h_52 in_25 vref 6.857615e-8
Gw1_26_52 0 sum_h_52 in_26 vref -6.387543e-10
Gw1_27_52 0 sum_h_52 in_27 vref -8.326534e-8
Gw1_28_52 0 sum_h_52 in_28 vref -9.107094e-8
Gw1_29_52 0 sum_h_52 in_29 vref -2.616036e-8
Gw1_30_52 0 sum_h_52 in_30 vref -2.900968e-8
Gw1_31_52 0 sum_h_52 in_31 vref 1.333386e-7
Gw1_32_52 0 sum_h_52 in_32 vref -1.870226e-8
Gw1_33_52 0 sum_h_52 in_33 vref -6.913938e-8
Gw1_34_52 0 sum_h_52 in_34 vref -9.148378e-8
Gw1_35_52 0 sum_h_52 in_35 vref 8.813495e-9
Gw1_36_52 0 sum_h_52 in_36 vref -5.515209e-10
Gw1_37_52 0 sum_h_52 in_37 vref -1.441230e-7
Gw1_38_52 0 sum_h_52 in_38 vref 2.411789e-8
Gw1_39_52 0 sum_h_52 in_39 vref -4.223039e-8
Gw1_40_52 0 sum_h_52 in_40 vref -1.070538e-7
Gw1_41_52 0 sum_h_52 in_41 vref -8.716938e-8
Gw1_42_52 0 sum_h_52 in_42 vref 7.313412e-8
Gw1_43_52 0 sum_h_52 in_43 vref -9.090113e-8
Gw1_44_52 0 sum_h_52 in_44 vref -1.558187e-7
Gw1_45_52 0 sum_h_52 in_45 vref -9.941090e-8
Gw1_46_52 0 sum_h_52 in_46 vref -1.447679e-8
Gw1_47_52 0 sum_h_52 in_47 vref -1.256946e-8
Gw1_48_52 0 sum_h_52 in_48 vref -1.109023e-7
Gw1_0_53 0 sum_h_53 in_0 vref 7.918798e-9
Gw1_1_53 0 sum_h_53 in_1 vref -1.165955e-7
Gw1_2_53 0 sum_h_53 in_2 vref -8.601145e-8
Gw1_3_53 0 sum_h_53 in_3 vref -4.240105e-8
Gw1_4_53 0 sum_h_53 in_4 vref -1.135757e-7
Gw1_5_53 0 sum_h_53 in_5 vref -5.182868e-8
Gw1_6_53 0 sum_h_53 in_6 vref 2.798486e-8
Gw1_7_53 0 sum_h_53 in_7 vref -1.818909e-7
Gw1_8_53 0 sum_h_53 in_8 vref -9.727439e-8
Gw1_9_53 0 sum_h_53 in_9 vref -6.041600e-8
Gw1_10_53 0 sum_h_53 in_10 vref -1.948866e-8
Gw1_11_53 0 sum_h_53 in_11 vref 5.773430e-10
Gw1_12_53 0 sum_h_53 in_12 vref 4.182813e-8
Gw1_13_53 0 sum_h_53 in_13 vref 7.947860e-8
Gw1_14_53 0 sum_h_53 in_14 vref -7.170972e-9
Gw1_15_53 0 sum_h_53 in_15 vref -9.926152e-8
Gw1_16_53 0 sum_h_53 in_16 vref 7.560041e-8
Gw1_17_53 0 sum_h_53 in_17 vref -7.524613e-9
Gw1_18_53 0 sum_h_53 in_18 vref 6.690815e-8
Gw1_19_53 0 sum_h_53 in_19 vref 1.905893e-7
Gw1_20_53 0 sum_h_53 in_20 vref -3.379294e-8
Gw1_21_53 0 sum_h_53 in_21 vref -1.289961e-8
Gw1_22_53 0 sum_h_53 in_22 vref 1.460768e-8
Gw1_23_53 0 sum_h_53 in_23 vref 9.305433e-8
Gw1_24_53 0 sum_h_53 in_24 vref 2.078386e-8
Gw1_25_53 0 sum_h_53 in_25 vref 1.552041e-8
Gw1_26_53 0 sum_h_53 in_26 vref -5.697434e-8
Gw1_27_53 0 sum_h_53 in_27 vref -1.897360e-7
Gw1_28_53 0 sum_h_53 in_28 vref -3.551293e-8
Gw1_29_53 0 sum_h_53 in_29 vref -1.331420e-7
Gw1_30_53 0 sum_h_53 in_30 vref -1.841241e-7
Gw1_31_53 0 sum_h_53 in_31 vref -6.465172e-8
Gw1_32_53 0 sum_h_53 in_32 vref -5.145794e-8
Gw1_33_53 0 sum_h_53 in_33 vref 7.386309e-8
Gw1_34_53 0 sum_h_53 in_34 vref -5.432440e-8
Gw1_35_53 0 sum_h_53 in_35 vref -1.379558e-7
Gw1_36_53 0 sum_h_53 in_36 vref -9.611529e-8
Gw1_37_53 0 sum_h_53 in_37 vref -1.185055e-7
Gw1_38_53 0 sum_h_53 in_38 vref -7.351933e-8
Gw1_39_53 0 sum_h_53 in_39 vref -1.802178e-7
Gw1_40_53 0 sum_h_53 in_40 vref -8.387752e-9
Gw1_41_53 0 sum_h_53 in_41 vref -3.413576e-8
Gw1_42_53 0 sum_h_53 in_42 vref -8.209515e-8
Gw1_43_53 0 sum_h_53 in_43 vref -9.827428e-11
Gw1_44_53 0 sum_h_53 in_44 vref 3.040098e-7
Gw1_45_53 0 sum_h_53 in_45 vref 1.827934e-7
Gw1_46_53 0 sum_h_53 in_46 vref -1.559541e-7
Gw1_47_53 0 sum_h_53 in_47 vref 5.154513e-8
Gw1_48_53 0 sum_h_53 in_48 vref -1.474511e-8
Gw1_0_54 0 sum_h_54 in_0 vref 7.033444e-8
Gw1_1_54 0 sum_h_54 in_1 vref -2.856856e-8
Gw1_2_54 0 sum_h_54 in_2 vref 8.124455e-8
Gw1_3_54 0 sum_h_54 in_3 vref 3.777507e-11
Gw1_4_54 0 sum_h_54 in_4 vref 7.548221e-8
Gw1_5_54 0 sum_h_54 in_5 vref -8.477426e-8
Gw1_6_54 0 sum_h_54 in_6 vref 1.110504e-7
Gw1_7_54 0 sum_h_54 in_7 vref 8.658615e-9
Gw1_8_54 0 sum_h_54 in_8 vref -1.601653e-8
Gw1_9_54 0 sum_h_54 in_9 vref -1.088686e-7
Gw1_10_54 0 sum_h_54 in_10 vref 4.429771e-8
Gw1_11_54 0 sum_h_54 in_11 vref 1.646701e-7
Gw1_12_54 0 sum_h_54 in_12 vref -2.504642e-8
Gw1_13_54 0 sum_h_54 in_13 vref 1.808580e-7
Gw1_14_54 0 sum_h_54 in_14 vref 3.207161e-8
Gw1_15_54 0 sum_h_54 in_15 vref -3.158363e-8
Gw1_16_54 0 sum_h_54 in_16 vref -1.475875e-7
Gw1_17_54 0 sum_h_54 in_17 vref 4.254147e-8
Gw1_18_54 0 sum_h_54 in_18 vref -1.466476e-7
Gw1_19_54 0 sum_h_54 in_19 vref -6.287496e-8
Gw1_20_54 0 sum_h_54 in_20 vref 5.204246e-8
Gw1_21_54 0 sum_h_54 in_21 vref -1.575526e-8
Gw1_22_54 0 sum_h_54 in_22 vref 5.295663e-8
Gw1_23_54 0 sum_h_54 in_23 vref -1.423182e-7
Gw1_24_54 0 sum_h_54 in_24 vref -1.360628e-7
Gw1_25_54 0 sum_h_54 in_25 vref -1.419312e-7
Gw1_26_54 0 sum_h_54 in_26 vref -4.975731e-8
Gw1_27_54 0 sum_h_54 in_27 vref 1.028255e-8
Gw1_28_54 0 sum_h_54 in_28 vref 4.108813e-8
Gw1_29_54 0 sum_h_54 in_29 vref 6.505907e-9
Gw1_30_54 0 sum_h_54 in_30 vref 5.898882e-8
Gw1_31_54 0 sum_h_54 in_31 vref 2.351241e-8
Gw1_32_54 0 sum_h_54 in_32 vref -2.283053e-8
Gw1_33_54 0 sum_h_54 in_33 vref -1.005879e-7
Gw1_34_54 0 sum_h_54 in_34 vref -7.153475e-8
Gw1_35_54 0 sum_h_54 in_35 vref -1.004018e-7
Gw1_36_54 0 sum_h_54 in_36 vref -6.990782e-8
Gw1_37_54 0 sum_h_54 in_37 vref -1.583696e-7
Gw1_38_54 0 sum_h_54 in_38 vref 2.447768e-8
Gw1_39_54 0 sum_h_54 in_39 vref 8.139838e-8
Gw1_40_54 0 sum_h_54 in_40 vref -1.156948e-7
Gw1_41_54 0 sum_h_54 in_41 vref 7.533449e-8
Gw1_42_54 0 sum_h_54 in_42 vref -4.958017e-8
Gw1_43_54 0 sum_h_54 in_43 vref -8.311323e-8
Gw1_44_54 0 sum_h_54 in_44 vref -5.838283e-8
Gw1_45_54 0 sum_h_54 in_45 vref 1.262674e-7
Gw1_46_54 0 sum_h_54 in_46 vref 1.709032e-7
Gw1_47_54 0 sum_h_54 in_47 vref -9.328215e-8
Gw1_48_54 0 sum_h_54 in_48 vref 1.574929e-7
Gw1_0_55 0 sum_h_55 in_0 vref -8.552972e-8
Gw1_1_55 0 sum_h_55 in_1 vref -6.067552e-8
Gw1_2_55 0 sum_h_55 in_2 vref 5.173527e-8
Gw1_3_55 0 sum_h_55 in_3 vref 1.330062e-7
Gw1_4_55 0 sum_h_55 in_4 vref -1.186011e-8
Gw1_5_55 0 sum_h_55 in_5 vref 3.802941e-8
Gw1_6_55 0 sum_h_55 in_6 vref 1.293777e-7
Gw1_7_55 0 sum_h_55 in_7 vref -9.196750e-8
Gw1_8_55 0 sum_h_55 in_8 vref 6.526479e-8
Gw1_9_55 0 sum_h_55 in_9 vref 4.827536e-8
Gw1_10_55 0 sum_h_55 in_10 vref -1.119498e-7
Gw1_11_55 0 sum_h_55 in_11 vref 8.620745e-8
Gw1_12_55 0 sum_h_55 in_12 vref 1.022816e-7
Gw1_13_55 0 sum_h_55 in_13 vref -5.247665e-8
Gw1_14_55 0 sum_h_55 in_14 vref -2.426603e-8
Gw1_15_55 0 sum_h_55 in_15 vref -4.266386e-8
Gw1_16_55 0 sum_h_55 in_16 vref -1.218038e-7
Gw1_17_55 0 sum_h_55 in_17 vref -1.671703e-8
Gw1_18_55 0 sum_h_55 in_18 vref 1.164331e-7
Gw1_19_55 0 sum_h_55 in_19 vref 6.649312e-8
Gw1_20_55 0 sum_h_55 in_20 vref -2.734457e-8
Gw1_21_55 0 sum_h_55 in_21 vref 1.530128e-7
Gw1_22_55 0 sum_h_55 in_22 vref 9.825379e-9
Gw1_23_55 0 sum_h_55 in_23 vref -4.195106e-8
Gw1_24_55 0 sum_h_55 in_24 vref 9.505669e-8
Gw1_25_55 0 sum_h_55 in_25 vref -9.508233e-8
Gw1_26_55 0 sum_h_55 in_26 vref -1.384726e-7
Gw1_27_55 0 sum_h_55 in_27 vref -8.625916e-8
Gw1_28_55 0 sum_h_55 in_28 vref 1.054474e-7
Gw1_29_55 0 sum_h_55 in_29 vref 1.261494e-7
Gw1_30_55 0 sum_h_55 in_30 vref -1.490233e-7
Gw1_31_55 0 sum_h_55 in_31 vref -5.712129e-8
Gw1_32_55 0 sum_h_55 in_32 vref 5.839319e-8
Gw1_33_55 0 sum_h_55 in_33 vref -9.354458e-8
Gw1_34_55 0 sum_h_55 in_34 vref -4.392082e-8
Gw1_35_55 0 sum_h_55 in_35 vref 1.005539e-7
Gw1_36_55 0 sum_h_55 in_36 vref 2.384366e-8
Gw1_37_55 0 sum_h_55 in_37 vref 8.166605e-8
Gw1_38_55 0 sum_h_55 in_38 vref 1.284808e-7
Gw1_39_55 0 sum_h_55 in_39 vref -1.617559e-7
Gw1_40_55 0 sum_h_55 in_40 vref -1.182122e-7
Gw1_41_55 0 sum_h_55 in_41 vref 4.640705e-8
Gw1_42_55 0 sum_h_55 in_42 vref 4.542746e-10
Gw1_43_55 0 sum_h_55 in_43 vref 2.134549e-7
Gw1_44_55 0 sum_h_55 in_44 vref -8.637272e-8
Gw1_45_55 0 sum_h_55 in_45 vref -2.130736e-7
Gw1_46_55 0 sum_h_55 in_46 vref -7.455255e-8
Gw1_47_55 0 sum_h_55 in_47 vref -3.894566e-8
Gw1_48_55 0 sum_h_55 in_48 vref 1.005203e-7
Gw1_0_56 0 sum_h_56 in_0 vref 6.449249e-8
Gw1_1_56 0 sum_h_56 in_1 vref 3.629166e-8
Gw1_2_56 0 sum_h_56 in_2 vref -3.347413e-8
Gw1_3_56 0 sum_h_56 in_3 vref 1.298921e-7
Gw1_4_56 0 sum_h_56 in_4 vref -1.001892e-7
Gw1_5_56 0 sum_h_56 in_5 vref -6.255540e-8
Gw1_6_56 0 sum_h_56 in_6 vref -6.768582e-8
Gw1_7_56 0 sum_h_56 in_7 vref 5.337889e-9
Gw1_8_56 0 sum_h_56 in_8 vref 9.418228e-8
Gw1_9_56 0 sum_h_56 in_9 vref 8.892543e-9
Gw1_10_56 0 sum_h_56 in_10 vref 4.422254e-8
Gw1_11_56 0 sum_h_56 in_11 vref 9.412803e-8
Gw1_12_56 0 sum_h_56 in_12 vref 1.354002e-8
Gw1_13_56 0 sum_h_56 in_13 vref 1.482894e-7
Gw1_14_56 0 sum_h_56 in_14 vref -1.159997e-7
Gw1_15_56 0 sum_h_56 in_15 vref 1.813606e-7
Gw1_16_56 0 sum_h_56 in_16 vref 1.934445e-7
Gw1_17_56 0 sum_h_56 in_17 vref 1.344311e-7
Gw1_18_56 0 sum_h_56 in_18 vref 3.025048e-9
Gw1_19_56 0 sum_h_56 in_19 vref -8.025071e-8
Gw1_20_56 0 sum_h_56 in_20 vref 6.628453e-8
Gw1_21_56 0 sum_h_56 in_21 vref 7.137301e-8
Gw1_22_56 0 sum_h_56 in_22 vref -5.158285e-8
Gw1_23_56 0 sum_h_56 in_23 vref -1.352314e-7
Gw1_24_56 0 sum_h_56 in_24 vref -1.000193e-7
Gw1_25_56 0 sum_h_56 in_25 vref 6.416769e-8
Gw1_26_56 0 sum_h_56 in_26 vref 7.046549e-9
Gw1_27_56 0 sum_h_56 in_27 vref -4.333978e-8
Gw1_28_56 0 sum_h_56 in_28 vref 7.276520e-8
Gw1_29_56 0 sum_h_56 in_29 vref -8.230727e-8
Gw1_30_56 0 sum_h_56 in_30 vref 5.715503e-8
Gw1_31_56 0 sum_h_56 in_31 vref 2.523346e-8
Gw1_32_56 0 sum_h_56 in_32 vref 6.864733e-8
Gw1_33_56 0 sum_h_56 in_33 vref -1.670252e-7
Gw1_34_56 0 sum_h_56 in_34 vref 7.664592e-8
Gw1_35_56 0 sum_h_56 in_35 vref -8.497001e-8
Gw1_36_56 0 sum_h_56 in_36 vref 1.862574e-7
Gw1_37_56 0 sum_h_56 in_37 vref 1.020687e-7
Gw1_38_56 0 sum_h_56 in_38 vref -2.201506e-8
Gw1_39_56 0 sum_h_56 in_39 vref -6.375045e-8
Gw1_40_56 0 sum_h_56 in_40 vref -5.533931e-8
Gw1_41_56 0 sum_h_56 in_41 vref -4.200909e-8
Gw1_42_56 0 sum_h_56 in_42 vref 9.797503e-8
Gw1_43_56 0 sum_h_56 in_43 vref -8.265048e-8
Gw1_44_56 0 sum_h_56 in_44 vref -8.018021e-8
Gw1_45_56 0 sum_h_56 in_45 vref 1.453394e-7
Gw1_46_56 0 sum_h_56 in_46 vref 5.161582e-8
Gw1_47_56 0 sum_h_56 in_47 vref -4.773607e-8
Gw1_48_56 0 sum_h_56 in_48 vref -1.037873e-8
Gw1_0_57 0 sum_h_57 in_0 vref -7.793035e-8
Gw1_1_57 0 sum_h_57 in_1 vref -1.031737e-7
Gw1_2_57 0 sum_h_57 in_2 vref 5.527898e-8
Gw1_3_57 0 sum_h_57 in_3 vref 6.595522e-8
Gw1_4_57 0 sum_h_57 in_4 vref 8.302434e-8
Gw1_5_57 0 sum_h_57 in_5 vref -3.378341e-8
Gw1_6_57 0 sum_h_57 in_6 vref -6.170266e-8
Gw1_7_57 0 sum_h_57 in_7 vref -2.475000e-8
Gw1_8_57 0 sum_h_57 in_8 vref -9.578803e-8
Gw1_9_57 0 sum_h_57 in_9 vref 2.618934e-8
Gw1_10_57 0 sum_h_57 in_10 vref 5.608639e-8
Gw1_11_57 0 sum_h_57 in_11 vref 8.584647e-9
Gw1_12_57 0 sum_h_57 in_12 vref -4.020394e-8
Gw1_13_57 0 sum_h_57 in_13 vref -6.677938e-10
Gw1_14_57 0 sum_h_57 in_14 vref 5.970379e-8
Gw1_15_57 0 sum_h_57 in_15 vref 4.541729e-8
Gw1_16_57 0 sum_h_57 in_16 vref -1.238227e-8
Gw1_17_57 0 sum_h_57 in_17 vref -3.749205e-8
Gw1_18_57 0 sum_h_57 in_18 vref 1.200465e-8
Gw1_19_57 0 sum_h_57 in_19 vref 9.518376e-8
Gw1_20_57 0 sum_h_57 in_20 vref 3.712206e-8
Gw1_21_57 0 sum_h_57 in_21 vref 4.891119e-8
Gw1_22_57 0 sum_h_57 in_22 vref -1.217850e-7
Gw1_23_57 0 sum_h_57 in_23 vref -1.380478e-7
Gw1_24_57 0 sum_h_57 in_24 vref 1.800866e-8
Gw1_25_57 0 sum_h_57 in_25 vref 4.695858e-8
Gw1_26_57 0 sum_h_57 in_26 vref 7.400306e-8
Gw1_27_57 0 sum_h_57 in_27 vref 1.159174e-7
Gw1_28_57 0 sum_h_57 in_28 vref 1.112737e-7
Gw1_29_57 0 sum_h_57 in_29 vref -9.567940e-8
Gw1_30_57 0 sum_h_57 in_30 vref 3.132671e-8
Gw1_31_57 0 sum_h_57 in_31 vref 7.169498e-8
Gw1_32_57 0 sum_h_57 in_32 vref 8.708775e-8
Gw1_33_57 0 sum_h_57 in_33 vref -7.458268e-8
Gw1_34_57 0 sum_h_57 in_34 vref -8.346277e-8
Gw1_35_57 0 sum_h_57 in_35 vref 9.361399e-8
Gw1_36_57 0 sum_h_57 in_36 vref 1.184348e-8
Gw1_37_57 0 sum_h_57 in_37 vref -1.912825e-8
Gw1_38_57 0 sum_h_57 in_38 vref -7.196030e-8
Gw1_39_57 0 sum_h_57 in_39 vref -1.469457e-7
Gw1_40_57 0 sum_h_57 in_40 vref 6.444166e-8
Gw1_41_57 0 sum_h_57 in_41 vref 9.443755e-8
Gw1_42_57 0 sum_h_57 in_42 vref -7.598121e-8
Gw1_43_57 0 sum_h_57 in_43 vref -5.847561e-8
Gw1_44_57 0 sum_h_57 in_44 vref -1.686570e-8
Gw1_45_57 0 sum_h_57 in_45 vref -1.161021e-7
Gw1_46_57 0 sum_h_57 in_46 vref -8.009837e-8
Gw1_47_57 0 sum_h_57 in_47 vref 1.340728e-7
Gw1_48_57 0 sum_h_57 in_48 vref -2.545789e-8
Gw1_0_58 0 sum_h_58 in_0 vref 5.201163e-8
Gw1_1_58 0 sum_h_58 in_1 vref 1.626073e-8
Gw1_2_58 0 sum_h_58 in_2 vref -1.121052e-8
Gw1_3_58 0 sum_h_58 in_3 vref -1.133779e-7
Gw1_4_58 0 sum_h_58 in_4 vref -7.363878e-8
Gw1_5_58 0 sum_h_58 in_5 vref 1.163518e-7
Gw1_6_58 0 sum_h_58 in_6 vref 8.917436e-8
Gw1_7_58 0 sum_h_58 in_7 vref 6.510844e-9
Gw1_8_58 0 sum_h_58 in_8 vref 8.211268e-8
Gw1_9_58 0 sum_h_58 in_9 vref 1.806441e-7
Gw1_10_58 0 sum_h_58 in_10 vref -5.100942e-9
Gw1_11_58 0 sum_h_58 in_11 vref -2.550462e-8
Gw1_12_58 0 sum_h_58 in_12 vref -8.745597e-8
Gw1_13_58 0 sum_h_58 in_13 vref -1.283831e-7
Gw1_14_58 0 sum_h_58 in_14 vref 8.638856e-8
Gw1_15_58 0 sum_h_58 in_15 vref -8.005312e-9
Gw1_16_58 0 sum_h_58 in_16 vref 1.346897e-8
Gw1_17_58 0 sum_h_58 in_17 vref 3.777915e-8
Gw1_18_58 0 sum_h_58 in_18 vref 6.243189e-8
Gw1_19_58 0 sum_h_58 in_19 vref -1.004040e-7
Gw1_20_58 0 sum_h_58 in_20 vref -4.080570e-8
Gw1_21_58 0 sum_h_58 in_21 vref -7.723418e-8
Gw1_22_58 0 sum_h_58 in_22 vref 1.223300e-8
Gw1_23_58 0 sum_h_58 in_23 vref 1.812423e-8
Gw1_24_58 0 sum_h_58 in_24 vref 5.650328e-8
Gw1_25_58 0 sum_h_58 in_25 vref 6.209508e-8
Gw1_26_58 0 sum_h_58 in_26 vref -1.194048e-7
Gw1_27_58 0 sum_h_58 in_27 vref 9.951437e-8
Gw1_28_58 0 sum_h_58 in_28 vref 8.888085e-8
Gw1_29_58 0 sum_h_58 in_29 vref -8.805073e-9
Gw1_30_58 0 sum_h_58 in_30 vref 6.859603e-9
Gw1_31_58 0 sum_h_58 in_31 vref 1.275294e-7
Gw1_32_58 0 sum_h_58 in_32 vref 6.882249e-8
Gw1_33_58 0 sum_h_58 in_33 vref 1.115699e-7
Gw1_34_58 0 sum_h_58 in_34 vref 1.351461e-7
Gw1_35_58 0 sum_h_58 in_35 vref -1.264469e-8
Gw1_36_58 0 sum_h_58 in_36 vref -5.876742e-8
Gw1_37_58 0 sum_h_58 in_37 vref -1.346995e-7
Gw1_38_58 0 sum_h_58 in_38 vref -1.326001e-7
Gw1_39_58 0 sum_h_58 in_39 vref -3.620258e-7
Gw1_40_58 0 sum_h_58 in_40 vref -2.892563e-7
Gw1_41_58 0 sum_h_58 in_41 vref -3.983319e-8
Gw1_42_58 0 sum_h_58 in_42 vref 1.158148e-7
Gw1_43_58 0 sum_h_58 in_43 vref 9.028281e-8
Gw1_44_58 0 sum_h_58 in_44 vref 6.109352e-8
Gw1_45_58 0 sum_h_58 in_45 vref -6.959313e-8
Gw1_46_58 0 sum_h_58 in_46 vref -3.670300e-8
Gw1_47_58 0 sum_h_58 in_47 vref -5.900022e-8
Gw1_48_58 0 sum_h_58 in_48 vref 1.057022e-7
Gw1_0_59 0 sum_h_59 in_0 vref -1.372595e-7
Gw1_1_59 0 sum_h_59 in_1 vref -1.524123e-7
Gw1_2_59 0 sum_h_59 in_2 vref -3.964491e-8
Gw1_3_59 0 sum_h_59 in_3 vref -2.848293e-8
Gw1_4_59 0 sum_h_59 in_4 vref -4.094367e-8
Gw1_5_59 0 sum_h_59 in_5 vref 4.898380e-8
Gw1_6_59 0 sum_h_59 in_6 vref 5.098602e-9
Gw1_7_59 0 sum_h_59 in_7 vref -1.074954e-7
Gw1_8_59 0 sum_h_59 in_8 vref -4.908667e-8
Gw1_9_59 0 sum_h_59 in_9 vref 6.475165e-8
Gw1_10_59 0 sum_h_59 in_10 vref 1.576375e-7
Gw1_11_59 0 sum_h_59 in_11 vref 4.703949e-8
Gw1_12_59 0 sum_h_59 in_12 vref 7.974806e-8
Gw1_13_59 0 sum_h_59 in_13 vref 8.690395e-9
Gw1_14_59 0 sum_h_59 in_14 vref 2.082911e-8
Gw1_15_59 0 sum_h_59 in_15 vref -1.458681e-8
Gw1_16_59 0 sum_h_59 in_16 vref -6.893923e-8
Gw1_17_59 0 sum_h_59 in_17 vref -1.716927e-7
Gw1_18_59 0 sum_h_59 in_18 vref 9.092309e-8
Gw1_19_59 0 sum_h_59 in_19 vref 6.330619e-8
Gw1_20_59 0 sum_h_59 in_20 vref -4.463579e-8
Gw1_21_59 0 sum_h_59 in_21 vref -1.271879e-7
Gw1_22_59 0 sum_h_59 in_22 vref -1.020658e-7
Gw1_23_59 0 sum_h_59 in_23 vref -1.741125e-7
Gw1_24_59 0 sum_h_59 in_24 vref -6.953687e-8
Gw1_25_59 0 sum_h_59 in_25 vref -1.764528e-7
Gw1_26_59 0 sum_h_59 in_26 vref -4.493189e-8
Gw1_27_59 0 sum_h_59 in_27 vref -1.000837e-7
Gw1_28_59 0 sum_h_59 in_28 vref 6.592759e-8
Gw1_29_59 0 sum_h_59 in_29 vref 1.149864e-7
Gw1_30_59 0 sum_h_59 in_30 vref 6.588453e-8
Gw1_31_59 0 sum_h_59 in_31 vref 9.388085e-8
Gw1_32_59 0 sum_h_59 in_32 vref -1.573723e-7
Gw1_33_59 0 sum_h_59 in_33 vref 1.286576e-8
Gw1_34_59 0 sum_h_59 in_34 vref 1.253154e-7
Gw1_35_59 0 sum_h_59 in_35 vref 1.075291e-7
Gw1_36_59 0 sum_h_59 in_36 vref -6.305530e-8
Gw1_37_59 0 sum_h_59 in_37 vref -7.218153e-8
Gw1_38_59 0 sum_h_59 in_38 vref 5.763535e-8
Gw1_39_59 0 sum_h_59 in_39 vref 1.711568e-7
Gw1_40_59 0 sum_h_59 in_40 vref 5.353459e-9
Gw1_41_59 0 sum_h_59 in_41 vref 2.808808e-8
Gw1_42_59 0 sum_h_59 in_42 vref -4.209969e-8
Gw1_43_59 0 sum_h_59 in_43 vref 1.419380e-7
Gw1_44_59 0 sum_h_59 in_44 vref 2.384967e-7
Gw1_45_59 0 sum_h_59 in_45 vref 1.033502e-7
Gw1_46_59 0 sum_h_59 in_46 vref 7.192370e-8
Gw1_47_59 0 sum_h_59 in_47 vref 8.162170e-8
Gw1_48_59 0 sum_h_59 in_48 vref 7.576595e-8
Gw1_0_60 0 sum_h_60 in_0 vref 3.965989e-8
Gw1_1_60 0 sum_h_60 in_1 vref 2.875846e-8
Gw1_2_60 0 sum_h_60 in_2 vref -1.597775e-8
Gw1_3_60 0 sum_h_60 in_3 vref 1.075981e-7
Gw1_4_60 0 sum_h_60 in_4 vref -4.187003e-8
Gw1_5_60 0 sum_h_60 in_5 vref 1.897638e-8
Gw1_6_60 0 sum_h_60 in_6 vref 5.594090e-8
Gw1_7_60 0 sum_h_60 in_7 vref -3.704300e-8
Gw1_8_60 0 sum_h_60 in_8 vref 5.923339e-8
Gw1_9_60 0 sum_h_60 in_9 vref 3.794650e-8
Gw1_10_60 0 sum_h_60 in_10 vref -1.675391e-8
Gw1_11_60 0 sum_h_60 in_11 vref 1.997709e-7
Gw1_12_60 0 sum_h_60 in_12 vref -5.003513e-8
Gw1_13_60 0 sum_h_60 in_13 vref -1.091739e-7
Gw1_14_60 0 sum_h_60 in_14 vref 2.511658e-9
Gw1_15_60 0 sum_h_60 in_15 vref 1.085906e-7
Gw1_16_60 0 sum_h_60 in_16 vref -1.003928e-8
Gw1_17_60 0 sum_h_60 in_17 vref -1.872683e-7
Gw1_18_60 0 sum_h_60 in_18 vref -2.492446e-7
Gw1_19_60 0 sum_h_60 in_19 vref -1.650880e-7
Gw1_20_60 0 sum_h_60 in_20 vref -1.651411e-8
Gw1_21_60 0 sum_h_60 in_21 vref 8.101158e-8
Gw1_22_60 0 sum_h_60 in_22 vref 5.308997e-8
Gw1_23_60 0 sum_h_60 in_23 vref 2.118572e-8
Gw1_24_60 0 sum_h_60 in_24 vref 1.296092e-7
Gw1_25_60 0 sum_h_60 in_25 vref -6.773948e-8
Gw1_26_60 0 sum_h_60 in_26 vref -6.035609e-8
Gw1_27_60 0 sum_h_60 in_27 vref -2.520480e-8
Gw1_28_60 0 sum_h_60 in_28 vref 1.231982e-7
Gw1_29_60 0 sum_h_60 in_29 vref 1.962252e-8
Gw1_30_60 0 sum_h_60 in_30 vref -5.993111e-8
Gw1_31_60 0 sum_h_60 in_31 vref -9.529075e-8
Gw1_32_60 0 sum_h_60 in_32 vref -5.522662e-8
Gw1_33_60 0 sum_h_60 in_33 vref -3.550395e-8
Gw1_34_60 0 sum_h_60 in_34 vref 1.706678e-8
Gw1_35_60 0 sum_h_60 in_35 vref -6.091446e-8
Gw1_36_60 0 sum_h_60 in_36 vref -5.278497e-8
Gw1_37_60 0 sum_h_60 in_37 vref 5.008999e-8
Gw1_38_60 0 sum_h_60 in_38 vref -2.476291e-8
Gw1_39_60 0 sum_h_60 in_39 vref 1.422615e-7
Gw1_40_60 0 sum_h_60 in_40 vref 2.611553e-8
Gw1_41_60 0 sum_h_60 in_41 vref 1.403538e-7
Gw1_42_60 0 sum_h_60 in_42 vref 4.075967e-8
Gw1_43_60 0 sum_h_60 in_43 vref -4.783418e-8
Gw1_44_60 0 sum_h_60 in_44 vref -1.470029e-8
Gw1_45_60 0 sum_h_60 in_45 vref 1.240904e-7
Gw1_46_60 0 sum_h_60 in_46 vref -2.540922e-8
Gw1_47_60 0 sum_h_60 in_47 vref 9.494260e-8
Gw1_48_60 0 sum_h_60 in_48 vref 4.511038e-8
Gw1_0_61 0 sum_h_61 in_0 vref 1.212824e-7
Gw1_1_61 0 sum_h_61 in_1 vref -7.710020e-8
Gw1_2_61 0 sum_h_61 in_2 vref -2.582700e-8
Gw1_3_61 0 sum_h_61 in_3 vref 6.267817e-8
Gw1_4_61 0 sum_h_61 in_4 vref 4.359833e-8
Gw1_5_61 0 sum_h_61 in_5 vref -4.964547e-8
Gw1_6_61 0 sum_h_61 in_6 vref 2.572155e-8
Gw1_7_61 0 sum_h_61 in_7 vref 1.430224e-8
Gw1_8_61 0 sum_h_61 in_8 vref 1.034836e-7
Gw1_9_61 0 sum_h_61 in_9 vref -1.192375e-7
Gw1_10_61 0 sum_h_61 in_10 vref 4.400823e-8
Gw1_11_61 0 sum_h_61 in_11 vref 1.107803e-7
Gw1_12_61 0 sum_h_61 in_12 vref 1.317004e-7
Gw1_13_61 0 sum_h_61 in_13 vref -1.045237e-7
Gw1_14_61 0 sum_h_61 in_14 vref -8.206744e-8
Gw1_15_61 0 sum_h_61 in_15 vref -3.008077e-8
Gw1_16_61 0 sum_h_61 in_16 vref -4.571449e-8
Gw1_17_61 0 sum_h_61 in_17 vref -1.043132e-7
Gw1_18_61 0 sum_h_61 in_18 vref 3.241869e-9
Gw1_19_61 0 sum_h_61 in_19 vref 1.551012e-7
Gw1_20_61 0 sum_h_61 in_20 vref -4.698494e-8
Gw1_21_61 0 sum_h_61 in_21 vref -6.387901e-8
Gw1_22_61 0 sum_h_61 in_22 vref 3.093516e-9
Gw1_23_61 0 sum_h_61 in_23 vref -5.649288e-8
Gw1_24_61 0 sum_h_61 in_24 vref 1.449615e-8
Gw1_25_61 0 sum_h_61 in_25 vref 9.843960e-8
Gw1_26_61 0 sum_h_61 in_26 vref -9.534200e-8
Gw1_27_61 0 sum_h_61 in_27 vref 8.476107e-8
Gw1_28_61 0 sum_h_61 in_28 vref 1.087200e-7
Gw1_29_61 0 sum_h_61 in_29 vref 1.049201e-7
Gw1_30_61 0 sum_h_61 in_30 vref -5.131641e-8
Gw1_31_61 0 sum_h_61 in_31 vref 8.600716e-8
Gw1_32_61 0 sum_h_61 in_32 vref -9.265518e-8
Gw1_33_61 0 sum_h_61 in_33 vref -6.735049e-8
Gw1_34_61 0 sum_h_61 in_34 vref -9.894936e-8
Gw1_35_61 0 sum_h_61 in_35 vref 1.414248e-7
Gw1_36_61 0 sum_h_61 in_36 vref 5.148787e-8
Gw1_37_61 0 sum_h_61 in_37 vref 1.384002e-8
Gw1_38_61 0 sum_h_61 in_38 vref -1.841368e-7
Gw1_39_61 0 sum_h_61 in_39 vref 8.751592e-9
Gw1_40_61 0 sum_h_61 in_40 vref -1.286693e-7
Gw1_41_61 0 sum_h_61 in_41 vref -1.046176e-7
Gw1_42_61 0 sum_h_61 in_42 vref 1.043045e-7
Gw1_43_61 0 sum_h_61 in_43 vref 2.049685e-8
Gw1_44_61 0 sum_h_61 in_44 vref -1.660160e-7
Gw1_45_61 0 sum_h_61 in_45 vref 9.341035e-9
Gw1_46_61 0 sum_h_61 in_46 vref 8.879763e-8
Gw1_47_61 0 sum_h_61 in_47 vref 1.286646e-9
Gw1_48_61 0 sum_h_61 in_48 vref -4.923456e-8
Gw1_0_62 0 sum_h_62 in_0 vref 1.195962e-7
Gw1_1_62 0 sum_h_62 in_1 vref -4.783143e-8
Gw1_2_62 0 sum_h_62 in_2 vref -3.900778e-8
Gw1_3_62 0 sum_h_62 in_3 vref 1.394187e-8
Gw1_4_62 0 sum_h_62 in_4 vref -1.834437e-8
Gw1_5_62 0 sum_h_62 in_5 vref 1.144089e-7
Gw1_6_62 0 sum_h_62 in_6 vref 1.314252e-7
Gw1_7_62 0 sum_h_62 in_7 vref 2.000866e-8
Gw1_8_62 0 sum_h_62 in_8 vref -1.847464e-8
Gw1_9_62 0 sum_h_62 in_9 vref -3.501396e-7
Gw1_10_62 0 sum_h_62 in_10 vref -4.746457e-9
Gw1_11_62 0 sum_h_62 in_11 vref 1.101674e-7
Gw1_12_62 0 sum_h_62 in_12 vref 8.669913e-9
Gw1_13_62 0 sum_h_62 in_13 vref 1.218329e-8
Gw1_14_62 0 sum_h_62 in_14 vref 4.575696e-8
Gw1_15_62 0 sum_h_62 in_15 vref 4.385666e-9
Gw1_16_62 0 sum_h_62 in_16 vref -9.135830e-9
Gw1_17_62 0 sum_h_62 in_17 vref -2.886628e-9
Gw1_18_62 0 sum_h_62 in_18 vref -4.897783e-8
Gw1_19_62 0 sum_h_62 in_19 vref 1.056770e-7
Gw1_20_62 0 sum_h_62 in_20 vref -7.929167e-9
Gw1_21_62 0 sum_h_62 in_21 vref 1.589477e-7
Gw1_22_62 0 sum_h_62 in_22 vref -8.779907e-8
Gw1_23_62 0 sum_h_62 in_23 vref -2.373032e-8
Gw1_24_62 0 sum_h_62 in_24 vref 1.103949e-7
Gw1_25_62 0 sum_h_62 in_25 vref -1.725002e-7
Gw1_26_62 0 sum_h_62 in_26 vref -3.197633e-8
Gw1_27_62 0 sum_h_62 in_27 vref 8.145923e-9
Gw1_28_62 0 sum_h_62 in_28 vref 1.029987e-7
Gw1_29_62 0 sum_h_62 in_29 vref 5.957185e-9
Gw1_30_62 0 sum_h_62 in_30 vref -1.051416e-7
Gw1_31_62 0 sum_h_62 in_31 vref 1.447768e-7
Gw1_32_62 0 sum_h_62 in_32 vref -2.609269e-7
Gw1_33_62 0 sum_h_62 in_33 vref -7.074847e-8
Gw1_34_62 0 sum_h_62 in_34 vref -1.393104e-8
Gw1_35_62 0 sum_h_62 in_35 vref -1.173791e-7
Gw1_36_62 0 sum_h_62 in_36 vref -4.646399e-10
Gw1_37_62 0 sum_h_62 in_37 vref 4.717151e-8
Gw1_38_62 0 sum_h_62 in_38 vref 1.155384e-7
Gw1_39_62 0 sum_h_62 in_39 vref -1.153861e-7
Gw1_40_62 0 sum_h_62 in_40 vref 6.352452e-8
Gw1_41_62 0 sum_h_62 in_41 vref 1.388507e-7
Gw1_42_62 0 sum_h_62 in_42 vref -9.148125e-8
Gw1_43_62 0 sum_h_62 in_43 vref 4.471320e-8
Gw1_44_62 0 sum_h_62 in_44 vref 8.273949e-8
Gw1_45_62 0 sum_h_62 in_45 vref 5.290289e-8
Gw1_46_62 0 sum_h_62 in_46 vref 1.672034e-8
Gw1_47_62 0 sum_h_62 in_47 vref 8.608463e-8
Gw1_48_62 0 sum_h_62 in_48 vref 7.703915e-8
Gw1_0_63 0 sum_h_63 in_0 vref 1.021344e-7
Gw1_1_63 0 sum_h_63 in_1 vref -5.467577e-8
Gw1_2_63 0 sum_h_63 in_2 vref 1.099717e-8
Gw1_3_63 0 sum_h_63 in_3 vref -9.375371e-8
Gw1_4_63 0 sum_h_63 in_4 vref -7.682378e-8
Gw1_5_63 0 sum_h_63 in_5 vref -5.423839e-9
Gw1_6_63 0 sum_h_63 in_6 vref 1.002462e-7
Gw1_7_63 0 sum_h_63 in_7 vref -3.642629e-8
Gw1_8_63 0 sum_h_63 in_8 vref -1.432363e-7
Gw1_9_63 0 sum_h_63 in_9 vref -6.052458e-8
Gw1_10_63 0 sum_h_63 in_10 vref 3.472329e-8
Gw1_11_63 0 sum_h_63 in_11 vref 1.088414e-7
Gw1_12_63 0 sum_h_63 in_12 vref 1.182161e-7
Gw1_13_63 0 sum_h_63 in_13 vref 2.113610e-8
Gw1_14_63 0 sum_h_63 in_14 vref -1.497138e-7
Gw1_15_63 0 sum_h_63 in_15 vref -7.398093e-8
Gw1_16_63 0 sum_h_63 in_16 vref -6.058801e-8
Gw1_17_63 0 sum_h_63 in_17 vref -1.104276e-7
Gw1_18_63 0 sum_h_63 in_18 vref 1.181428e-9
Gw1_19_63 0 sum_h_63 in_19 vref 2.551411e-7
Gw1_20_63 0 sum_h_63 in_20 vref -5.012802e-8
Gw1_21_63 0 sum_h_63 in_21 vref -8.893416e-8
Gw1_22_63 0 sum_h_63 in_22 vref 1.535100e-9
Gw1_23_63 0 sum_h_63 in_23 vref -1.011370e-7
Gw1_24_63 0 sum_h_63 in_24 vref -4.022097e-8
Gw1_25_63 0 sum_h_63 in_25 vref 7.079221e-8
Gw1_26_63 0 sum_h_63 in_26 vref 1.046172e-7
Gw1_27_63 0 sum_h_63 in_27 vref 8.967004e-8
Gw1_28_63 0 sum_h_63 in_28 vref 7.288462e-8
Gw1_29_63 0 sum_h_63 in_29 vref 4.221310e-9
Gw1_30_63 0 sum_h_63 in_30 vref 9.203732e-8
Gw1_31_63 0 sum_h_63 in_31 vref -6.256860e-8
Gw1_32_63 0 sum_h_63 in_32 vref -1.502931e-7
Gw1_33_63 0 sum_h_63 in_33 vref -2.046056e-7
Gw1_34_63 0 sum_h_63 in_34 vref 5.604261e-8
Gw1_35_63 0 sum_h_63 in_35 vref -8.246762e-8
Gw1_36_63 0 sum_h_63 in_36 vref 5.595779e-8
Gw1_37_63 0 sum_h_63 in_37 vref -6.971613e-8
Gw1_38_63 0 sum_h_63 in_38 vref 7.349420e-8
Gw1_39_63 0 sum_h_63 in_39 vref -5.423470e-8
Gw1_40_63 0 sum_h_63 in_40 vref -9.569295e-8
Gw1_41_63 0 sum_h_63 in_41 vref 7.086204e-8
Gw1_42_63 0 sum_h_63 in_42 vref -6.945525e-8
Gw1_43_63 0 sum_h_63 in_43 vref -1.276786e-7
Gw1_44_63 0 sum_h_63 in_44 vref 8.460696e-8
Gw1_45_63 0 sum_h_63 in_45 vref 8.414123e-8
Gw1_46_63 0 sum_h_63 in_46 vref -1.785279e-8
Gw1_47_63 0 sum_h_63 in_47 vref 7.045752e-8
Gw1_48_63 0 sum_h_63 in_48 vref 1.116213e-7
Gw1_0_64 0 sum_h_64 in_0 vref 1.146860e-7
Gw1_1_64 0 sum_h_64 in_1 vref -3.278724e-8
Gw1_2_64 0 sum_h_64 in_2 vref 3.176188e-8
Gw1_3_64 0 sum_h_64 in_3 vref -1.249958e-7
Gw1_4_64 0 sum_h_64 in_4 vref 5.146666e-8
Gw1_5_64 0 sum_h_64 in_5 vref 1.407476e-7
Gw1_6_64 0 sum_h_64 in_6 vref -7.424571e-8
Gw1_7_64 0 sum_h_64 in_7 vref -9.834709e-8
Gw1_8_64 0 sum_h_64 in_8 vref -1.415936e-7
Gw1_9_64 0 sum_h_64 in_9 vref -1.265277e-7
Gw1_10_64 0 sum_h_64 in_10 vref 2.825452e-8
Gw1_11_64 0 sum_h_64 in_11 vref 2.484586e-7
Gw1_12_64 0 sum_h_64 in_12 vref -4.818198e-8
Gw1_13_64 0 sum_h_64 in_13 vref -7.755757e-8
Gw1_14_64 0 sum_h_64 in_14 vref -1.361451e-7
Gw1_15_64 0 sum_h_64 in_15 vref 2.941688e-8
Gw1_16_64 0 sum_h_64 in_16 vref -6.108959e-8
Gw1_17_64 0 sum_h_64 in_17 vref 3.419759e-8
Gw1_18_64 0 sum_h_64 in_18 vref -4.745224e-8
Gw1_19_64 0 sum_h_64 in_19 vref 1.806413e-7
Gw1_20_64 0 sum_h_64 in_20 vref -3.329432e-8
Gw1_21_64 0 sum_h_64 in_21 vref -1.107178e-7
Gw1_22_64 0 sum_h_64 in_22 vref -4.948213e-9
Gw1_23_64 0 sum_h_64 in_23 vref -2.523660e-8
Gw1_24_64 0 sum_h_64 in_24 vref 1.099556e-7
Gw1_25_64 0 sum_h_64 in_25 vref -8.773036e-8
Gw1_26_64 0 sum_h_64 in_26 vref 6.577528e-8
Gw1_27_64 0 sum_h_64 in_27 vref 4.017342e-8
Gw1_28_64 0 sum_h_64 in_28 vref 1.241693e-7
Gw1_29_64 0 sum_h_64 in_29 vref -9.484012e-9
Gw1_30_64 0 sum_h_64 in_30 vref 2.490338e-8
Gw1_31_64 0 sum_h_64 in_31 vref -1.356543e-7
Gw1_32_64 0 sum_h_64 in_32 vref -3.929316e-8
Gw1_33_64 0 sum_h_64 in_33 vref 2.618274e-8
Gw1_34_64 0 sum_h_64 in_34 vref -5.849655e-8
Gw1_35_64 0 sum_h_64 in_35 vref -9.782222e-8
Gw1_36_64 0 sum_h_64 in_36 vref -2.444303e-8
Gw1_37_64 0 sum_h_64 in_37 vref 1.831324e-7
Gw1_38_64 0 sum_h_64 in_38 vref 1.049309e-7
Gw1_39_64 0 sum_h_64 in_39 vref 9.254752e-8
Gw1_40_64 0 sum_h_64 in_40 vref -9.247478e-8
Gw1_41_64 0 sum_h_64 in_41 vref 6.071411e-9
Gw1_42_64 0 sum_h_64 in_42 vref -1.372811e-7
Gw1_43_64 0 sum_h_64 in_43 vref 4.439504e-8
Gw1_44_64 0 sum_h_64 in_44 vref -7.060761e-8
Gw1_45_64 0 sum_h_64 in_45 vref 3.156017e-8
Gw1_46_64 0 sum_h_64 in_46 vref -3.688283e-8
Gw1_47_64 0 sum_h_64 in_47 vref -8.427626e-9
Gw1_48_64 0 sum_h_64 in_48 vref -5.397731e-8
Gw1_0_65 0 sum_h_65 in_0 vref 3.082054e-8
Gw1_1_65 0 sum_h_65 in_1 vref -6.522984e-8
Gw1_2_65 0 sum_h_65 in_2 vref 3.769903e-8
Gw1_3_65 0 sum_h_65 in_3 vref -1.141945e-7
Gw1_4_65 0 sum_h_65 in_4 vref -1.335550e-7
Gw1_5_65 0 sum_h_65 in_5 vref -1.142247e-7
Gw1_6_65 0 sum_h_65 in_6 vref -6.118967e-8
Gw1_7_65 0 sum_h_65 in_7 vref 3.452894e-8
Gw1_8_65 0 sum_h_65 in_8 vref -1.211498e-7
Gw1_9_65 0 sum_h_65 in_9 vref 8.647378e-8
Gw1_10_65 0 sum_h_65 in_10 vref -4.736205e-8
Gw1_11_65 0 sum_h_65 in_11 vref 7.982131e-9
Gw1_12_65 0 sum_h_65 in_12 vref -1.623059e-9
Gw1_13_65 0 sum_h_65 in_13 vref 9.140334e-8
Gw1_14_65 0 sum_h_65 in_14 vref 9.500164e-8
Gw1_15_65 0 sum_h_65 in_15 vref -1.759082e-8
Gw1_16_65 0 sum_h_65 in_16 vref 7.846931e-8
Gw1_17_65 0 sum_h_65 in_17 vref -1.291523e-9
Gw1_18_65 0 sum_h_65 in_18 vref 1.505223e-7
Gw1_19_65 0 sum_h_65 in_19 vref 7.455514e-8
Gw1_20_65 0 sum_h_65 in_20 vref 1.911862e-7
Gw1_21_65 0 sum_h_65 in_21 vref 5.424982e-8
Gw1_22_65 0 sum_h_65 in_22 vref 1.458128e-7
Gw1_23_65 0 sum_h_65 in_23 vref 1.284534e-7
Gw1_24_65 0 sum_h_65 in_24 vref 6.522995e-8
Gw1_25_65 0 sum_h_65 in_25 vref -8.455483e-8
Gw1_26_65 0 sum_h_65 in_26 vref 5.513887e-8
Gw1_27_65 0 sum_h_65 in_27 vref 3.020653e-8
Gw1_28_65 0 sum_h_65 in_28 vref -1.557111e-7
Gw1_29_65 0 sum_h_65 in_29 vref -9.698911e-8
Gw1_30_65 0 sum_h_65 in_30 vref -2.310305e-8
Gw1_31_65 0 sum_h_65 in_31 vref 6.448166e-9
Gw1_32_65 0 sum_h_65 in_32 vref -1.936298e-7
Gw1_33_65 0 sum_h_65 in_33 vref -1.202152e-7
Gw1_34_65 0 sum_h_65 in_34 vref 2.025443e-8
Gw1_35_65 0 sum_h_65 in_35 vref -1.653007e-7
Gw1_36_65 0 sum_h_65 in_36 vref -1.665883e-7
Gw1_37_65 0 sum_h_65 in_37 vref 9.710899e-8
Gw1_38_65 0 sum_h_65 in_38 vref 5.230565e-8
Gw1_39_65 0 sum_h_65 in_39 vref -3.354626e-9
Gw1_40_65 0 sum_h_65 in_40 vref -2.755901e-8
Gw1_41_65 0 sum_h_65 in_41 vref -1.340679e-7
Gw1_42_65 0 sum_h_65 in_42 vref 1.952597e-8
Gw1_43_65 0 sum_h_65 in_43 vref -1.509874e-7
Gw1_44_65 0 sum_h_65 in_44 vref -6.210804e-8
Gw1_45_65 0 sum_h_65 in_45 vref -1.158158e-7
Gw1_46_65 0 sum_h_65 in_46 vref -2.204191e-8
Gw1_47_65 0 sum_h_65 in_47 vref 3.473062e-8
Gw1_48_65 0 sum_h_65 in_48 vref 4.950724e-8
Gw1_0_66 0 sum_h_66 in_0 vref -1.448309e-8
Gw1_1_66 0 sum_h_66 in_1 vref -3.170223e-8
Gw1_2_66 0 sum_h_66 in_2 vref -6.279728e-8
Gw1_3_66 0 sum_h_66 in_3 vref 5.305145e-8
Gw1_4_66 0 sum_h_66 in_4 vref -6.191060e-8
Gw1_5_66 0 sum_h_66 in_5 vref 3.087760e-8
Gw1_6_66 0 sum_h_66 in_6 vref 6.451540e-8
Gw1_7_66 0 sum_h_66 in_7 vref -5.954039e-8
Gw1_8_66 0 sum_h_66 in_8 vref -7.351886e-8
Gw1_9_66 0 sum_h_66 in_9 vref -1.228215e-7
Gw1_10_66 0 sum_h_66 in_10 vref -9.349246e-9
Gw1_11_66 0 sum_h_66 in_11 vref -1.443573e-7
Gw1_12_66 0 sum_h_66 in_12 vref 4.563361e-8
Gw1_13_66 0 sum_h_66 in_13 vref 1.157118e-7
Gw1_14_66 0 sum_h_66 in_14 vref -1.480786e-7
Gw1_15_66 0 sum_h_66 in_15 vref 1.329783e-8
Gw1_16_66 0 sum_h_66 in_16 vref 1.158108e-8
Gw1_17_66 0 sum_h_66 in_17 vref -5.134794e-8
Gw1_18_66 0 sum_h_66 in_18 vref -8.092231e-8
Gw1_19_66 0 sum_h_66 in_19 vref -2.884917e-8
Gw1_20_66 0 sum_h_66 in_20 vref -2.812363e-8
Gw1_21_66 0 sum_h_66 in_21 vref 6.861796e-8
Gw1_22_66 0 sum_h_66 in_22 vref 7.343980e-8
Gw1_23_66 0 sum_h_66 in_23 vref 1.263479e-7
Gw1_24_66 0 sum_h_66 in_24 vref 1.383467e-7
Gw1_25_66 0 sum_h_66 in_25 vref 6.727193e-8
Gw1_26_66 0 sum_h_66 in_26 vref 3.555654e-10
Gw1_27_66 0 sum_h_66 in_27 vref 2.615151e-8
Gw1_28_66 0 sum_h_66 in_28 vref 5.421962e-9
Gw1_29_66 0 sum_h_66 in_29 vref 1.239494e-7
Gw1_30_66 0 sum_h_66 in_30 vref -7.532436e-8
Gw1_31_66 0 sum_h_66 in_31 vref 2.827189e-8
Gw1_32_66 0 sum_h_66 in_32 vref 1.836435e-7
Gw1_33_66 0 sum_h_66 in_33 vref 6.642996e-8
Gw1_34_66 0 sum_h_66 in_34 vref -1.250335e-7
Gw1_35_66 0 sum_h_66 in_35 vref -1.761776e-8
Gw1_36_66 0 sum_h_66 in_36 vref -5.962823e-8
Gw1_37_66 0 sum_h_66 in_37 vref -5.272714e-8
Gw1_38_66 0 sum_h_66 in_38 vref 3.732154e-8
Gw1_39_66 0 sum_h_66 in_39 vref 7.473087e-8
Gw1_40_66 0 sum_h_66 in_40 vref 1.462993e-7
Gw1_41_66 0 sum_h_66 in_41 vref -5.955623e-8
Gw1_42_66 0 sum_h_66 in_42 vref -9.489509e-9
Gw1_43_66 0 sum_h_66 in_43 vref -4.731370e-8
Gw1_44_66 0 sum_h_66 in_44 vref -9.306137e-8
Gw1_45_66 0 sum_h_66 in_45 vref -9.941918e-8
Gw1_46_66 0 sum_h_66 in_46 vref -1.634467e-7
Gw1_47_66 0 sum_h_66 in_47 vref -1.541110e-7
Gw1_48_66 0 sum_h_66 in_48 vref -9.450836e-8
Gw1_0_67 0 sum_h_67 in_0 vref 4.610787e-8
Gw1_1_67 0 sum_h_67 in_1 vref 3.930379e-8
Gw1_2_67 0 sum_h_67 in_2 vref 1.729899e-7
Gw1_3_67 0 sum_h_67 in_3 vref 2.089881e-7
Gw1_4_67 0 sum_h_67 in_4 vref 4.595496e-8
Gw1_5_67 0 sum_h_67 in_5 vref 1.467320e-7
Gw1_6_67 0 sum_h_67 in_6 vref -1.758435e-8
Gw1_7_67 0 sum_h_67 in_7 vref -8.141180e-8
Gw1_8_67 0 sum_h_67 in_8 vref -1.475450e-9
Gw1_9_67 0 sum_h_67 in_9 vref -6.849096e-8
Gw1_10_67 0 sum_h_67 in_10 vref -1.393207e-7
Gw1_11_67 0 sum_h_67 in_11 vref -1.674817e-7
Gw1_12_67 0 sum_h_67 in_12 vref -5.007269e-8
Gw1_13_67 0 sum_h_67 in_13 vref -1.843501e-7
Gw1_14_67 0 sum_h_67 in_14 vref -1.708220e-7
Gw1_15_67 0 sum_h_67 in_15 vref -9.617767e-8
Gw1_16_67 0 sum_h_67 in_16 vref -1.144931e-8
Gw1_17_67 0 sum_h_67 in_17 vref -1.007657e-7
Gw1_18_67 0 sum_h_67 in_18 vref -1.290179e-7
Gw1_19_67 0 sum_h_67 in_19 vref -8.516371e-8
Gw1_20_67 0 sum_h_67 in_20 vref -1.404932e-8
Gw1_21_67 0 sum_h_67 in_21 vref 6.551926e-8
Gw1_22_67 0 sum_h_67 in_22 vref 1.115393e-7
Gw1_23_67 0 sum_h_67 in_23 vref -5.280381e-8
Gw1_24_67 0 sum_h_67 in_24 vref 6.139788e-8
Gw1_25_67 0 sum_h_67 in_25 vref 3.694922e-8
Gw1_26_67 0 sum_h_67 in_26 vref 1.089605e-7
Gw1_27_67 0 sum_h_67 in_27 vref -6.202273e-8
Gw1_28_67 0 sum_h_67 in_28 vref 2.134407e-8
Gw1_29_67 0 sum_h_67 in_29 vref 3.365080e-8
Gw1_30_67 0 sum_h_67 in_30 vref 7.263003e-8
Gw1_31_67 0 sum_h_67 in_31 vref 2.479351e-8
Gw1_32_67 0 sum_h_67 in_32 vref -3.607840e-8
Gw1_33_67 0 sum_h_67 in_33 vref 4.236120e-8
Gw1_34_67 0 sum_h_67 in_34 vref 7.964910e-8
Gw1_35_67 0 sum_h_67 in_35 vref 7.077407e-9
Gw1_36_67 0 sum_h_67 in_36 vref 7.955662e-8
Gw1_37_67 0 sum_h_67 in_37 vref 3.311478e-8
Gw1_38_67 0 sum_h_67 in_38 vref 1.352061e-7
Gw1_39_67 0 sum_h_67 in_39 vref 4.380178e-8
Gw1_40_67 0 sum_h_67 in_40 vref -2.387051e-7
Gw1_41_67 0 sum_h_67 in_41 vref -2.086865e-7
Gw1_42_67 0 sum_h_67 in_42 vref -7.677799e-8
Gw1_43_67 0 sum_h_67 in_43 vref -6.143865e-8
Gw1_44_67 0 sum_h_67 in_44 vref -1.208237e-7
Gw1_45_67 0 sum_h_67 in_45 vref -3.136027e-7
Gw1_46_67 0 sum_h_67 in_46 vref -1.917803e-7
Gw1_47_67 0 sum_h_67 in_47 vref -1.538121e-7
Gw1_48_67 0 sum_h_67 in_48 vref -5.774308e-8
Gw1_0_68 0 sum_h_68 in_0 vref -6.741720e-8
Gw1_1_68 0 sum_h_68 in_1 vref 6.373802e-8
Gw1_2_68 0 sum_h_68 in_2 vref -2.960205e-8
Gw1_3_68 0 sum_h_68 in_3 vref -5.078799e-8
Gw1_4_68 0 sum_h_68 in_4 vref 2.848415e-8
Gw1_5_68 0 sum_h_68 in_5 vref -2.378243e-8
Gw1_6_68 0 sum_h_68 in_6 vref -1.375353e-7
Gw1_7_68 0 sum_h_68 in_7 vref -1.299812e-7
Gw1_8_68 0 sum_h_68 in_8 vref -3.341106e-8
Gw1_9_68 0 sum_h_68 in_9 vref 1.035225e-7
Gw1_10_68 0 sum_h_68 in_10 vref -7.601835e-8
Gw1_11_68 0 sum_h_68 in_11 vref -1.350373e-7
Gw1_12_68 0 sum_h_68 in_12 vref -9.240301e-9
Gw1_13_68 0 sum_h_68 in_13 vref -8.093295e-9
Gw1_14_68 0 sum_h_68 in_14 vref -1.013334e-8
Gw1_15_68 0 sum_h_68 in_15 vref -1.500107e-7
Gw1_16_68 0 sum_h_68 in_16 vref -4.518858e-8
Gw1_17_68 0 sum_h_68 in_17 vref 1.083797e-7
Gw1_18_68 0 sum_h_68 in_18 vref 3.231108e-10
Gw1_19_68 0 sum_h_68 in_19 vref -1.213484e-7
Gw1_20_68 0 sum_h_68 in_20 vref 6.010228e-8
Gw1_21_68 0 sum_h_68 in_21 vref -1.184766e-7
Gw1_22_68 0 sum_h_68 in_22 vref -4.145101e-8
Gw1_23_68 0 sum_h_68 in_23 vref 1.134721e-7
Gw1_24_68 0 sum_h_68 in_24 vref 4.047801e-8
Gw1_25_68 0 sum_h_68 in_25 vref -9.904039e-8
Gw1_26_68 0 sum_h_68 in_26 vref -1.633434e-7
Gw1_27_68 0 sum_h_68 in_27 vref -7.010291e-8
Gw1_28_68 0 sum_h_68 in_28 vref 3.742403e-8
Gw1_29_68 0 sum_h_68 in_29 vref 5.842425e-8
Gw1_30_68 0 sum_h_68 in_30 vref 3.988247e-9
Gw1_31_68 0 sum_h_68 in_31 vref 4.933443e-8
Gw1_32_68 0 sum_h_68 in_32 vref 9.611276e-8
Gw1_33_68 0 sum_h_68 in_33 vref 2.151062e-7
Gw1_34_68 0 sum_h_68 in_34 vref 6.286813e-8
Gw1_35_68 0 sum_h_68 in_35 vref 1.063421e-7
Gw1_36_68 0 sum_h_68 in_36 vref -3.227749e-8
Gw1_37_68 0 sum_h_68 in_37 vref 1.040075e-7
Gw1_38_68 0 sum_h_68 in_38 vref 1.459108e-7
Gw1_39_68 0 sum_h_68 in_39 vref 1.872718e-8
Gw1_40_68 0 sum_h_68 in_40 vref 5.110397e-9
Gw1_41_68 0 sum_h_68 in_41 vref -8.855121e-9
Gw1_42_68 0 sum_h_68 in_42 vref 1.358648e-7
Gw1_43_68 0 sum_h_68 in_43 vref -9.574345e-8
Gw1_44_68 0 sum_h_68 in_44 vref 1.277377e-8
Gw1_45_68 0 sum_h_68 in_45 vref -1.659176e-7
Gw1_46_68 0 sum_h_68 in_46 vref -3.888635e-8
Gw1_47_68 0 sum_h_68 in_47 vref 4.053016e-8
Gw1_48_68 0 sum_h_68 in_48 vref -1.009084e-7
Gw1_0_69 0 sum_h_69 in_0 vref -9.161024e-8
Gw1_1_69 0 sum_h_69 in_1 vref -4.389931e-8
Gw1_2_69 0 sum_h_69 in_2 vref 1.036944e-7
Gw1_3_69 0 sum_h_69 in_3 vref 9.263188e-8
Gw1_4_69 0 sum_h_69 in_4 vref 1.320504e-7
Gw1_5_69 0 sum_h_69 in_5 vref -9.524292e-8
Gw1_6_69 0 sum_h_69 in_6 vref 6.992073e-8
Gw1_7_69 0 sum_h_69 in_7 vref -4.416766e-8
Gw1_8_69 0 sum_h_69 in_8 vref -4.721516e-8
Gw1_9_69 0 sum_h_69 in_9 vref -1.796072e-7
Gw1_10_69 0 sum_h_69 in_10 vref -3.990843e-8
Gw1_11_69 0 sum_h_69 in_11 vref 1.019609e-7
Gw1_12_69 0 sum_h_69 in_12 vref -7.290744e-8
Gw1_13_69 0 sum_h_69 in_13 vref 7.550777e-8
Gw1_14_69 0 sum_h_69 in_14 vref 4.576449e-8
Gw1_15_69 0 sum_h_69 in_15 vref -3.681661e-8
Gw1_16_69 0 sum_h_69 in_16 vref 2.384972e-8
Gw1_17_69 0 sum_h_69 in_17 vref -1.408389e-8
Gw1_18_69 0 sum_h_69 in_18 vref 1.527351e-7
Gw1_19_69 0 sum_h_69 in_19 vref -5.910243e-9
Gw1_20_69 0 sum_h_69 in_20 vref -1.495284e-7
Gw1_21_69 0 sum_h_69 in_21 vref -1.534092e-8
Gw1_22_69 0 sum_h_69 in_22 vref -1.142732e-7
Gw1_23_69 0 sum_h_69 in_23 vref -8.189365e-9
Gw1_24_69 0 sum_h_69 in_24 vref -1.369404e-8
Gw1_25_69 0 sum_h_69 in_25 vref 1.147723e-7
Gw1_26_69 0 sum_h_69 in_26 vref -1.380439e-7
Gw1_27_69 0 sum_h_69 in_27 vref -7.071554e-8
Gw1_28_69 0 sum_h_69 in_28 vref -9.503162e-8
Gw1_29_69 0 sum_h_69 in_29 vref -1.651931e-7
Gw1_30_69 0 sum_h_69 in_30 vref 4.403822e-8
Gw1_31_69 0 sum_h_69 in_31 vref -4.774198e-8
Gw1_32_69 0 sum_h_69 in_32 vref -1.260494e-7
Gw1_33_69 0 sum_h_69 in_33 vref -1.183609e-7
Gw1_34_69 0 sum_h_69 in_34 vref -3.262000e-8
Gw1_35_69 0 sum_h_69 in_35 vref 1.058805e-7
Gw1_36_69 0 sum_h_69 in_36 vref -5.409255e-8
Gw1_37_69 0 sum_h_69 in_37 vref 1.345567e-8
Gw1_38_69 0 sum_h_69 in_38 vref 7.604558e-8
Gw1_39_69 0 sum_h_69 in_39 vref 5.357273e-8
Gw1_40_69 0 sum_h_69 in_40 vref 1.485967e-7
Gw1_41_69 0 sum_h_69 in_41 vref 1.700631e-7
Gw1_42_69 0 sum_h_69 in_42 vref -8.179076e-9
Gw1_43_69 0 sum_h_69 in_43 vref 5.528769e-8
Gw1_44_69 0 sum_h_69 in_44 vref 5.982055e-8
Gw1_45_69 0 sum_h_69 in_45 vref 2.182079e-8
Gw1_46_69 0 sum_h_69 in_46 vref 5.302552e-8
Gw1_47_69 0 sum_h_69 in_47 vref 1.617433e-8
Gw1_48_69 0 sum_h_69 in_48 vref 1.386828e-7
Gw1_0_70 0 sum_h_70 in_0 vref -9.935446e-8
Gw1_1_70 0 sum_h_70 in_1 vref 1.100893e-7
Gw1_2_70 0 sum_h_70 in_2 vref -3.040262e-8
Gw1_3_70 0 sum_h_70 in_3 vref -7.758555e-8
Gw1_4_70 0 sum_h_70 in_4 vref 1.671890e-8
Gw1_5_70 0 sum_h_70 in_5 vref 3.532119e-8
Gw1_6_70 0 sum_h_70 in_6 vref 6.987845e-8
Gw1_7_70 0 sum_h_70 in_7 vref -1.025726e-7
Gw1_8_70 0 sum_h_70 in_8 vref 1.072973e-7
Gw1_9_70 0 sum_h_70 in_9 vref -1.616726e-8
Gw1_10_70 0 sum_h_70 in_10 vref 5.508465e-9
Gw1_11_70 0 sum_h_70 in_11 vref -1.053963e-7
Gw1_12_70 0 sum_h_70 in_12 vref -6.799521e-8
Gw1_13_70 0 sum_h_70 in_13 vref 2.463798e-8
Gw1_14_70 0 sum_h_70 in_14 vref -7.523118e-8
Gw1_15_70 0 sum_h_70 in_15 vref -4.837414e-8
Gw1_16_70 0 sum_h_70 in_16 vref -2.520454e-8
Gw1_17_70 0 sum_h_70 in_17 vref -2.888595e-8
Gw1_18_70 0 sum_h_70 in_18 vref -9.494842e-8
Gw1_19_70 0 sum_h_70 in_19 vref 1.378681e-7
Gw1_20_70 0 sum_h_70 in_20 vref 5.180495e-8
Gw1_21_70 0 sum_h_70 in_21 vref -3.406194e-8
Gw1_22_70 0 sum_h_70 in_22 vref 1.544263e-7
Gw1_23_70 0 sum_h_70 in_23 vref 8.549950e-8
Gw1_24_70 0 sum_h_70 in_24 vref -5.533837e-8
Gw1_25_70 0 sum_h_70 in_25 vref 1.468765e-7
Gw1_26_70 0 sum_h_70 in_26 vref 8.129764e-8
Gw1_27_70 0 sum_h_70 in_27 vref 4.735027e-8
Gw1_28_70 0 sum_h_70 in_28 vref -3.381090e-9
Gw1_29_70 0 sum_h_70 in_29 vref -1.965529e-7
Gw1_30_70 0 sum_h_70 in_30 vref -9.892687e-8
Gw1_31_70 0 sum_h_70 in_31 vref 3.070426e-8
Gw1_32_70 0 sum_h_70 in_32 vref -1.674445e-7
Gw1_33_70 0 sum_h_70 in_33 vref -8.549522e-8
Gw1_34_70 0 sum_h_70 in_34 vref 5.828915e-8
Gw1_35_70 0 sum_h_70 in_35 vref 5.254790e-8
Gw1_36_70 0 sum_h_70 in_36 vref 2.234527e-8
Gw1_37_70 0 sum_h_70 in_37 vref -1.233792e-7
Gw1_38_70 0 sum_h_70 in_38 vref 1.429050e-7
Gw1_39_70 0 sum_h_70 in_39 vref -1.031042e-7
Gw1_40_70 0 sum_h_70 in_40 vref -1.307637e-7
Gw1_41_70 0 sum_h_70 in_41 vref -1.026084e-7
Gw1_42_70 0 sum_h_70 in_42 vref 6.362627e-8
Gw1_43_70 0 sum_h_70 in_43 vref -9.811546e-8
Gw1_44_70 0 sum_h_70 in_44 vref -6.230735e-8
Gw1_45_70 0 sum_h_70 in_45 vref 1.594531e-7
Gw1_46_70 0 sum_h_70 in_46 vref -7.029104e-8
Gw1_47_70 0 sum_h_70 in_47 vref -1.107568e-7
Gw1_48_70 0 sum_h_70 in_48 vref -3.511626e-9
Gw1_0_71 0 sum_h_71 in_0 vref 1.247372e-7
Gw1_1_71 0 sum_h_71 in_1 vref 1.190923e-7
Gw1_2_71 0 sum_h_71 in_2 vref -1.287638e-7
Gw1_3_71 0 sum_h_71 in_3 vref -8.643334e-8
Gw1_4_71 0 sum_h_71 in_4 vref -8.367991e-8
Gw1_5_71 0 sum_h_71 in_5 vref 6.230564e-8
Gw1_6_71 0 sum_h_71 in_6 vref 3.278843e-8
Gw1_7_71 0 sum_h_71 in_7 vref 1.173715e-7
Gw1_8_71 0 sum_h_71 in_8 vref -5.733279e-8
Gw1_9_71 0 sum_h_71 in_9 vref -7.141767e-8
Gw1_10_71 0 sum_h_71 in_10 vref -2.517793e-8
Gw1_11_71 0 sum_h_71 in_11 vref 1.108354e-7
Gw1_12_71 0 sum_h_71 in_12 vref -2.388485e-8
Gw1_13_71 0 sum_h_71 in_13 vref -5.430574e-8
Gw1_14_71 0 sum_h_71 in_14 vref -1.146352e-7
Gw1_15_71 0 sum_h_71 in_15 vref -1.861977e-7
Gw1_16_71 0 sum_h_71 in_16 vref 6.982834e-8
Gw1_17_71 0 sum_h_71 in_17 vref -1.435734e-7
Gw1_18_71 0 sum_h_71 in_18 vref -1.280439e-7
Gw1_19_71 0 sum_h_71 in_19 vref -5.507107e-8
Gw1_20_71 0 sum_h_71 in_20 vref -1.388327e-7
Gw1_21_71 0 sum_h_71 in_21 vref -1.642433e-8
Gw1_22_71 0 sum_h_71 in_22 vref 3.422944e-8
Gw1_23_71 0 sum_h_71 in_23 vref 1.742692e-7
Gw1_24_71 0 sum_h_71 in_24 vref 6.671475e-8
Gw1_25_71 0 sum_h_71 in_25 vref 1.238431e-7
Gw1_26_71 0 sum_h_71 in_26 vref -1.479323e-7
Gw1_27_71 0 sum_h_71 in_27 vref 1.022745e-7
Gw1_28_71 0 sum_h_71 in_28 vref -3.449715e-8
Gw1_29_71 0 sum_h_71 in_29 vref 8.348820e-8
Gw1_30_71 0 sum_h_71 in_30 vref -2.578476e-8
Gw1_31_71 0 sum_h_71 in_31 vref -1.786531e-9
Gw1_32_71 0 sum_h_71 in_32 vref 1.107393e-7
Gw1_33_71 0 sum_h_71 in_33 vref 4.209160e-8
Gw1_34_71 0 sum_h_71 in_34 vref 9.697371e-11
Gw1_35_71 0 sum_h_71 in_35 vref -4.446992e-8
Gw1_36_71 0 sum_h_71 in_36 vref -5.627742e-8
Gw1_37_71 0 sum_h_71 in_37 vref -6.378168e-8
Gw1_38_71 0 sum_h_71 in_38 vref -9.627210e-8
Gw1_39_71 0 sum_h_71 in_39 vref -2.442394e-7
Gw1_40_71 0 sum_h_71 in_40 vref -2.884341e-8
Gw1_41_71 0 sum_h_71 in_41 vref 7.592736e-8
Gw1_42_71 0 sum_h_71 in_42 vref 6.986339e-8
Gw1_43_71 0 sum_h_71 in_43 vref 9.126970e-8
Gw1_44_71 0 sum_h_71 in_44 vref -8.132543e-8
Gw1_45_71 0 sum_h_71 in_45 vref 2.844848e-9
Gw1_46_71 0 sum_h_71 in_46 vref -1.413593e-7
Gw1_47_71 0 sum_h_71 in_47 vref -3.469589e-8
Gw1_48_71 0 sum_h_71 in_48 vref -1.140320e-7
Gw1_0_72 0 sum_h_72 in_0 vref 8.031575e-8
Gw1_1_72 0 sum_h_72 in_1 vref -8.844791e-8
Gw1_2_72 0 sum_h_72 in_2 vref -9.197060e-8
Gw1_3_72 0 sum_h_72 in_3 vref -1.631606e-8
Gw1_4_72 0 sum_h_72 in_4 vref -1.213289e-7
Gw1_5_72 0 sum_h_72 in_5 vref 7.948848e-9
Gw1_6_72 0 sum_h_72 in_6 vref 1.054448e-7
Gw1_7_72 0 sum_h_72 in_7 vref -3.228757e-8
Gw1_8_72 0 sum_h_72 in_8 vref 8.067470e-8
Gw1_9_72 0 sum_h_72 in_9 vref -1.525445e-7
Gw1_10_72 0 sum_h_72 in_10 vref -1.990015e-7
Gw1_11_72 0 sum_h_72 in_11 vref -1.649736e-7
Gw1_12_72 0 sum_h_72 in_12 vref 1.605473e-8
Gw1_13_72 0 sum_h_72 in_13 vref -1.621545e-7
Gw1_14_72 0 sum_h_72 in_14 vref -7.201490e-8
Gw1_15_72 0 sum_h_72 in_15 vref -4.286004e-8
Gw1_16_72 0 sum_h_72 in_16 vref -3.432006e-7
Gw1_17_72 0 sum_h_72 in_17 vref -1.569938e-7
Gw1_18_72 0 sum_h_72 in_18 vref 1.015317e-7
Gw1_19_72 0 sum_h_72 in_19 vref -3.148911e-9
Gw1_20_72 0 sum_h_72 in_20 vref 1.811039e-7
Gw1_21_72 0 sum_h_72 in_21 vref -7.199840e-8
Gw1_22_72 0 sum_h_72 in_22 vref -1.315547e-7
Gw1_23_72 0 sum_h_72 in_23 vref -6.355634e-8
Gw1_24_72 0 sum_h_72 in_24 vref -5.258028e-9
Gw1_25_72 0 sum_h_72 in_25 vref -9.011962e-8
Gw1_26_72 0 sum_h_72 in_26 vref -8.060535e-8
Gw1_27_72 0 sum_h_72 in_27 vref -1.235450e-7
Gw1_28_72 0 sum_h_72 in_28 vref 8.479309e-8
Gw1_29_72 0 sum_h_72 in_29 vref -1.718882e-8
Gw1_30_72 0 sum_h_72 in_30 vref 4.110845e-8
Gw1_31_72 0 sum_h_72 in_31 vref -9.135703e-9
Gw1_32_72 0 sum_h_72 in_32 vref -2.643891e-7
Gw1_33_72 0 sum_h_72 in_33 vref -1.122991e-7
Gw1_34_72 0 sum_h_72 in_34 vref 1.167111e-7
Gw1_35_72 0 sum_h_72 in_35 vref -2.911416e-8
Gw1_36_72 0 sum_h_72 in_36 vref -2.350231e-8
Gw1_37_72 0 sum_h_72 in_37 vref -1.968347e-7
Gw1_38_72 0 sum_h_72 in_38 vref -8.957311e-8
Gw1_39_72 0 sum_h_72 in_39 vref -1.784424e-7
Gw1_40_72 0 sum_h_72 in_40 vref -4.238429e-8
Gw1_41_72 0 sum_h_72 in_41 vref 5.107613e-8
Gw1_42_72 0 sum_h_72 in_42 vref 7.931406e-8
Gw1_43_72 0 sum_h_72 in_43 vref -1.794483e-7
Gw1_44_72 0 sum_h_72 in_44 vref -4.629639e-8
Gw1_45_72 0 sum_h_72 in_45 vref -7.435170e-8
Gw1_46_72 0 sum_h_72 in_46 vref -1.006861e-7
Gw1_47_72 0 sum_h_72 in_47 vref 6.597958e-8
Gw1_48_72 0 sum_h_72 in_48 vref -5.006576e-9
Gw1_0_73 0 sum_h_73 in_0 vref -1.012505e-7
Gw1_1_73 0 sum_h_73 in_1 vref 1.111642e-7
Gw1_2_73 0 sum_h_73 in_2 vref 8.934690e-8
Gw1_3_73 0 sum_h_73 in_3 vref -8.088809e-8
Gw1_4_73 0 sum_h_73 in_4 vref -1.976361e-8
Gw1_5_73 0 sum_h_73 in_5 vref 2.471938e-8
Gw1_6_73 0 sum_h_73 in_6 vref -1.886638e-8
Gw1_7_73 0 sum_h_73 in_7 vref -8.358642e-8
Gw1_8_73 0 sum_h_73 in_8 vref 1.082003e-7
Gw1_9_73 0 sum_h_73 in_9 vref 7.033271e-8
Gw1_10_73 0 sum_h_73 in_10 vref -2.093079e-7
Gw1_11_73 0 sum_h_73 in_11 vref 3.848385e-8
Gw1_12_73 0 sum_h_73 in_12 vref 6.822003e-9
Gw1_13_73 0 sum_h_73 in_13 vref 4.118870e-8
Gw1_14_73 0 sum_h_73 in_14 vref 7.579648e-8
Gw1_15_73 0 sum_h_73 in_15 vref 6.014048e-9
Gw1_16_73 0 sum_h_73 in_16 vref 1.112127e-7
Gw1_17_73 0 sum_h_73 in_17 vref -2.327319e-7
Gw1_18_73 0 sum_h_73 in_18 vref 9.079753e-8
Gw1_19_73 0 sum_h_73 in_19 vref 3.336926e-9
Gw1_20_73 0 sum_h_73 in_20 vref 6.383910e-8
Gw1_21_73 0 sum_h_73 in_21 vref 6.140353e-8
Gw1_22_73 0 sum_h_73 in_22 vref 2.727797e-9
Gw1_23_73 0 sum_h_73 in_23 vref 1.784341e-7
Gw1_24_73 0 sum_h_73 in_24 vref -2.224013e-7
Gw1_25_73 0 sum_h_73 in_25 vref -5.081751e-9
Gw1_26_73 0 sum_h_73 in_26 vref -7.487079e-8
Gw1_27_73 0 sum_h_73 in_27 vref -3.572191e-8
Gw1_28_73 0 sum_h_73 in_28 vref -1.712589e-7
Gw1_29_73 0 sum_h_73 in_29 vref 6.690052e-8
Gw1_30_73 0 sum_h_73 in_30 vref 7.596494e-9
Gw1_31_73 0 sum_h_73 in_31 vref -1.066196e-7
Gw1_32_73 0 sum_h_73 in_32 vref 1.063691e-7
Gw1_33_73 0 sum_h_73 in_33 vref 1.742705e-7
Gw1_34_73 0 sum_h_73 in_34 vref 4.072291e-8
Gw1_35_73 0 sum_h_73 in_35 vref -1.054357e-7
Gw1_36_73 0 sum_h_73 in_36 vref 7.159482e-8
Gw1_37_73 0 sum_h_73 in_37 vref 1.582409e-8
Gw1_38_73 0 sum_h_73 in_38 vref 6.358618e-8
Gw1_39_73 0 sum_h_73 in_39 vref -5.912471e-8
Gw1_40_73 0 sum_h_73 in_40 vref -9.411825e-8
Gw1_41_73 0 sum_h_73 in_41 vref 3.604604e-8
Gw1_42_73 0 sum_h_73 in_42 vref -6.844462e-9
Gw1_43_73 0 sum_h_73 in_43 vref -1.160392e-7
Gw1_44_73 0 sum_h_73 in_44 vref 6.656643e-9
Gw1_45_73 0 sum_h_73 in_45 vref -7.040455e-8
Gw1_46_73 0 sum_h_73 in_46 vref -3.458538e-8
Gw1_47_73 0 sum_h_73 in_47 vref -1.815584e-8
Gw1_48_73 0 sum_h_73 in_48 vref 5.502585e-8
Gw1_0_74 0 sum_h_74 in_0 vref -9.916959e-8
Gw1_1_74 0 sum_h_74 in_1 vref 1.128163e-7
Gw1_2_74 0 sum_h_74 in_2 vref -3.140797e-8
Gw1_3_74 0 sum_h_74 in_3 vref -2.882753e-8
Gw1_4_74 0 sum_h_74 in_4 vref -1.247885e-7
Gw1_5_74 0 sum_h_74 in_5 vref 6.738248e-8
Gw1_6_74 0 sum_h_74 in_6 vref 7.201264e-8
Gw1_7_74 0 sum_h_74 in_7 vref 3.080338e-8
Gw1_8_74 0 sum_h_74 in_8 vref 6.049026e-9
Gw1_9_74 0 sum_h_74 in_9 vref 8.419751e-8
Gw1_10_74 0 sum_h_74 in_10 vref 8.349588e-8
Gw1_11_74 0 sum_h_74 in_11 vref 2.241364e-8
Gw1_12_74 0 sum_h_74 in_12 vref -1.311156e-7
Gw1_13_74 0 sum_h_74 in_13 vref -7.638031e-9
Gw1_14_74 0 sum_h_74 in_14 vref 1.099737e-7
Gw1_15_74 0 sum_h_74 in_15 vref 1.431789e-7
Gw1_16_74 0 sum_h_74 in_16 vref -1.953788e-8
Gw1_17_74 0 sum_h_74 in_17 vref 5.931814e-8
Gw1_18_74 0 sum_h_74 in_18 vref 2.282305e-8
Gw1_19_74 0 sum_h_74 in_19 vref -4.532075e-8
Gw1_20_74 0 sum_h_74 in_20 vref -1.596040e-7
Gw1_21_74 0 sum_h_74 in_21 vref -5.619834e-9
Gw1_22_74 0 sum_h_74 in_22 vref 3.335785e-8
Gw1_23_74 0 sum_h_74 in_23 vref -2.836745e-8
Gw1_24_74 0 sum_h_74 in_24 vref 9.632885e-8
Gw1_25_74 0 sum_h_74 in_25 vref 3.891126e-8
Gw1_26_74 0 sum_h_74 in_26 vref -1.352557e-8
Gw1_27_74 0 sum_h_74 in_27 vref 9.035586e-8
Gw1_28_74 0 sum_h_74 in_28 vref -5.419598e-8
Gw1_29_74 0 sum_h_74 in_29 vref -2.193798e-7
Gw1_30_74 0 sum_h_74 in_30 vref -2.112874e-7
Gw1_31_74 0 sum_h_74 in_31 vref -1.650228e-7
Gw1_32_74 0 sum_h_74 in_32 vref 4.541441e-8
Gw1_33_74 0 sum_h_74 in_33 vref -3.833230e-8
Gw1_34_74 0 sum_h_74 in_34 vref -6.715549e-8
Gw1_35_74 0 sum_h_74 in_35 vref -6.048737e-8
Gw1_36_74 0 sum_h_74 in_36 vref 1.515565e-7
Gw1_37_74 0 sum_h_74 in_37 vref 6.391489e-8
Gw1_38_74 0 sum_h_74 in_38 vref -3.812655e-8
Gw1_39_74 0 sum_h_74 in_39 vref -1.500850e-7
Gw1_40_74 0 sum_h_74 in_40 vref -1.540959e-7
Gw1_41_74 0 sum_h_74 in_41 vref -1.470140e-7
Gw1_42_74 0 sum_h_74 in_42 vref -1.312441e-7
Gw1_43_74 0 sum_h_74 in_43 vref 1.889839e-7
Gw1_44_74 0 sum_h_74 in_44 vref 1.842435e-7
Gw1_45_74 0 sum_h_74 in_45 vref 4.171898e-8
Gw1_46_74 0 sum_h_74 in_46 vref -2.488370e-8
Gw1_47_74 0 sum_h_74 in_47 vref 5.055568e-8
Gw1_48_74 0 sum_h_74 in_48 vref -5.020783e-8
Gw1_0_75 0 sum_h_75 in_0 vref -1.886616e-8
Gw1_1_75 0 sum_h_75 in_1 vref -9.852171e-8
Gw1_2_75 0 sum_h_75 in_2 vref 1.657086e-7
Gw1_3_75 0 sum_h_75 in_3 vref 2.502250e-7
Gw1_4_75 0 sum_h_75 in_4 vref -1.050414e-7
Gw1_5_75 0 sum_h_75 in_5 vref 8.916312e-8
Gw1_6_75 0 sum_h_75 in_6 vref -8.664600e-8
Gw1_7_75 0 sum_h_75 in_7 vref 7.993879e-8
Gw1_8_75 0 sum_h_75 in_8 vref 1.445193e-7
Gw1_9_75 0 sum_h_75 in_9 vref 1.129253e-7
Gw1_10_75 0 sum_h_75 in_10 vref 2.523304e-7
Gw1_11_75 0 sum_h_75 in_11 vref 1.495331e-7
Gw1_12_75 0 sum_h_75 in_12 vref 1.446487e-7
Gw1_13_75 0 sum_h_75 in_13 vref -1.367760e-7
Gw1_14_75 0 sum_h_75 in_14 vref -4.157172e-8
Gw1_15_75 0 sum_h_75 in_15 vref 7.044443e-8
Gw1_16_75 0 sum_h_75 in_16 vref 2.588564e-8
Gw1_17_75 0 sum_h_75 in_17 vref -8.964772e-8
Gw1_18_75 0 sum_h_75 in_18 vref -1.171909e-7
Gw1_19_75 0 sum_h_75 in_19 vref -1.921062e-7
Gw1_20_75 0 sum_h_75 in_20 vref -2.564814e-8
Gw1_21_75 0 sum_h_75 in_21 vref -1.488503e-8
Gw1_22_75 0 sum_h_75 in_22 vref -9.057939e-8
Gw1_23_75 0 sum_h_75 in_23 vref -7.090800e-8
Gw1_24_75 0 sum_h_75 in_24 vref 6.587110e-8
Gw1_25_75 0 sum_h_75 in_25 vref 1.667088e-8
Gw1_26_75 0 sum_h_75 in_26 vref -4.366148e-8
Gw1_27_75 0 sum_h_75 in_27 vref -2.779795e-8
Gw1_28_75 0 sum_h_75 in_28 vref -7.992581e-8
Gw1_29_75 0 sum_h_75 in_29 vref -1.249963e-7
Gw1_30_75 0 sum_h_75 in_30 vref -7.377526e-9
Gw1_31_75 0 sum_h_75 in_31 vref -1.763823e-9
Gw1_32_75 0 sum_h_75 in_32 vref 8.971520e-10
Gw1_33_75 0 sum_h_75 in_33 vref 6.830793e-8
Gw1_34_75 0 sum_h_75 in_34 vref 3.649539e-9
Gw1_35_75 0 sum_h_75 in_35 vref -9.442941e-8
Gw1_36_75 0 sum_h_75 in_36 vref 2.444273e-8
Gw1_37_75 0 sum_h_75 in_37 vref 6.235091e-8
Gw1_38_75 0 sum_h_75 in_38 vref 1.267349e-7
Gw1_39_75 0 sum_h_75 in_39 vref 6.575308e-8
Gw1_40_75 0 sum_h_75 in_40 vref 1.219558e-7
Gw1_41_75 0 sum_h_75 in_41 vref 4.014039e-8
Gw1_42_75 0 sum_h_75 in_42 vref 6.688016e-9
Gw1_43_75 0 sum_h_75 in_43 vref 9.905607e-8
Gw1_44_75 0 sum_h_75 in_44 vref -2.112838e-8
Gw1_45_75 0 sum_h_75 in_45 vref 1.782863e-7
Gw1_46_75 0 sum_h_75 in_46 vref 1.054844e-7
Gw1_47_75 0 sum_h_75 in_47 vref -1.369728e-7
Gw1_48_75 0 sum_h_75 in_48 vref -4.970554e-8
Gw1_0_76 0 sum_h_76 in_0 vref -1.091672e-7
Gw1_1_76 0 sum_h_76 in_1 vref 8.074478e-8
Gw1_2_76 0 sum_h_76 in_2 vref -8.019029e-8
Gw1_3_76 0 sum_h_76 in_3 vref 1.798578e-8
Gw1_4_76 0 sum_h_76 in_4 vref -1.418371e-7
Gw1_5_76 0 sum_h_76 in_5 vref 5.673861e-8
Gw1_6_76 0 sum_h_76 in_6 vref -6.971143e-8
Gw1_7_76 0 sum_h_76 in_7 vref 1.874303e-9
Gw1_8_76 0 sum_h_76 in_8 vref -1.640053e-7
Gw1_9_76 0 sum_h_76 in_9 vref -1.363796e-7
Gw1_10_76 0 sum_h_76 in_10 vref 6.883896e-8
Gw1_11_76 0 sum_h_76 in_11 vref 1.836264e-8
Gw1_12_76 0 sum_h_76 in_12 vref 8.177651e-10
Gw1_13_76 0 sum_h_76 in_13 vref -6.629806e-10
Gw1_14_76 0 sum_h_76 in_14 vref -7.122738e-8
Gw1_15_76 0 sum_h_76 in_15 vref -1.379544e-7
Gw1_16_76 0 sum_h_76 in_16 vref -1.085551e-7
Gw1_17_76 0 sum_h_76 in_17 vref 1.985719e-7
Gw1_18_76 0 sum_h_76 in_18 vref 1.134030e-7
Gw1_19_76 0 sum_h_76 in_19 vref 1.473488e-7
Gw1_20_76 0 sum_h_76 in_20 vref 2.616337e-7
Gw1_21_76 0 sum_h_76 in_21 vref -5.784110e-8
Gw1_22_76 0 sum_h_76 in_22 vref 1.518644e-7
Gw1_23_76 0 sum_h_76 in_23 vref -6.854422e-8
Gw1_24_76 0 sum_h_76 in_24 vref 8.654214e-8
Gw1_25_76 0 sum_h_76 in_25 vref -6.680083e-8
Gw1_26_76 0 sum_h_76 in_26 vref -2.248747e-8
Gw1_27_76 0 sum_h_76 in_27 vref 1.192600e-7
Gw1_28_76 0 sum_h_76 in_28 vref -1.698235e-7
Gw1_29_76 0 sum_h_76 in_29 vref 3.879039e-8
Gw1_30_76 0 sum_h_76 in_30 vref 1.160243e-7
Gw1_31_76 0 sum_h_76 in_31 vref -1.265400e-7
Gw1_32_76 0 sum_h_76 in_32 vref -1.295267e-8
Gw1_33_76 0 sum_h_76 in_33 vref 6.183937e-8
Gw1_34_76 0 sum_h_76 in_34 vref -3.125212e-8
Gw1_35_76 0 sum_h_76 in_35 vref 5.043468e-8
Gw1_36_76 0 sum_h_76 in_36 vref 3.379218e-8
Gw1_37_76 0 sum_h_76 in_37 vref -1.542350e-9
Gw1_38_76 0 sum_h_76 in_38 vref -7.007396e-8
Gw1_39_76 0 sum_h_76 in_39 vref -5.394333e-8
Gw1_40_76 0 sum_h_76 in_40 vref 8.307715e-8
Gw1_41_76 0 sum_h_76 in_41 vref -5.920681e-9
Gw1_42_76 0 sum_h_76 in_42 vref 7.918234e-8
Gw1_43_76 0 sum_h_76 in_43 vref -1.887450e-7
Gw1_44_76 0 sum_h_76 in_44 vref 5.737180e-8
Gw1_45_76 0 sum_h_76 in_45 vref 1.976717e-7
Gw1_46_76 0 sum_h_76 in_46 vref 1.668965e-7
Gw1_47_76 0 sum_h_76 in_47 vref 1.206681e-8
Gw1_48_76 0 sum_h_76 in_48 vref 3.556875e-8
Gw1_0_77 0 sum_h_77 in_0 vref -3.690829e-8
Gw1_1_77 0 sum_h_77 in_1 vref 9.134308e-8
Gw1_2_77 0 sum_h_77 in_2 vref 2.898098e-8
Gw1_3_77 0 sum_h_77 in_3 vref -1.024528e-9
Gw1_4_77 0 sum_h_77 in_4 vref 4.266036e-8
Gw1_5_77 0 sum_h_77 in_5 vref 1.880334e-7
Gw1_6_77 0 sum_h_77 in_6 vref 1.221300e-7
Gw1_7_77 0 sum_h_77 in_7 vref -4.891439e-8
Gw1_8_77 0 sum_h_77 in_8 vref 3.499895e-9
Gw1_9_77 0 sum_h_77 in_9 vref 5.798131e-8
Gw1_10_77 0 sum_h_77 in_10 vref -7.698885e-8
Gw1_11_77 0 sum_h_77 in_11 vref 1.606737e-7
Gw1_12_77 0 sum_h_77 in_12 vref 1.526234e-7
Gw1_13_77 0 sum_h_77 in_13 vref -1.672893e-8
Gw1_14_77 0 sum_h_77 in_14 vref 1.385612e-8
Gw1_15_77 0 sum_h_77 in_15 vref -1.698968e-7
Gw1_16_77 0 sum_h_77 in_16 vref 3.860792e-8
Gw1_17_77 0 sum_h_77 in_17 vref 1.103232e-7
Gw1_18_77 0 sum_h_77 in_18 vref -1.800072e-7
Gw1_19_77 0 sum_h_77 in_19 vref -2.412373e-7
Gw1_20_77 0 sum_h_77 in_20 vref 2.690689e-8
Gw1_21_77 0 sum_h_77 in_21 vref -1.188706e-7
Gw1_22_77 0 sum_h_77 in_22 vref -4.186816e-8
Gw1_23_77 0 sum_h_77 in_23 vref 1.616713e-8
Gw1_24_77 0 sum_h_77 in_24 vref 5.641881e-8
Gw1_25_77 0 sum_h_77 in_25 vref 8.838757e-8
Gw1_26_77 0 sum_h_77 in_26 vref -8.227331e-8
Gw1_27_77 0 sum_h_77 in_27 vref -6.185517e-9
Gw1_28_77 0 sum_h_77 in_28 vref 7.110262e-8
Gw1_29_77 0 sum_h_77 in_29 vref -5.349164e-8
Gw1_30_77 0 sum_h_77 in_30 vref -6.523456e-8
Gw1_31_77 0 sum_h_77 in_31 vref 1.049040e-7
Gw1_32_77 0 sum_h_77 in_32 vref -1.184529e-7
Gw1_33_77 0 sum_h_77 in_33 vref -8.409111e-8
Gw1_34_77 0 sum_h_77 in_34 vref -7.931219e-8
Gw1_35_77 0 sum_h_77 in_35 vref 6.912657e-8
Gw1_36_77 0 sum_h_77 in_36 vref -2.239306e-7
Gw1_37_77 0 sum_h_77 in_37 vref -2.207431e-8
Gw1_38_77 0 sum_h_77 in_38 vref 9.413618e-9
Gw1_39_77 0 sum_h_77 in_39 vref -7.599173e-8
Gw1_40_77 0 sum_h_77 in_40 vref -1.558865e-7
Gw1_41_77 0 sum_h_77 in_41 vref -4.295297e-8
Gw1_42_77 0 sum_h_77 in_42 vref -8.034375e-8
Gw1_43_77 0 sum_h_77 in_43 vref 6.079092e-9
Gw1_44_77 0 sum_h_77 in_44 vref 1.499868e-7
Gw1_45_77 0 sum_h_77 in_45 vref -1.814162e-8
Gw1_46_77 0 sum_h_77 in_46 vref 1.739991e-9
Gw1_47_77 0 sum_h_77 in_47 vref -1.113233e-7
Gw1_48_77 0 sum_h_77 in_48 vref 6.262730e-8
Gw1_0_78 0 sum_h_78 in_0 vref 1.144210e-7
Gw1_1_78 0 sum_h_78 in_1 vref -3.664340e-8
Gw1_2_78 0 sum_h_78 in_2 vref -1.068617e-7
Gw1_3_78 0 sum_h_78 in_3 vref 4.478580e-8
Gw1_4_78 0 sum_h_78 in_4 vref -7.267456e-8
Gw1_5_78 0 sum_h_78 in_5 vref 2.071963e-8
Gw1_6_78 0 sum_h_78 in_6 vref 5.343932e-8
Gw1_7_78 0 sum_h_78 in_7 vref 8.732791e-8
Gw1_8_78 0 sum_h_78 in_8 vref -4.972402e-9
Gw1_9_78 0 sum_h_78 in_9 vref 1.382102e-7
Gw1_10_78 0 sum_h_78 in_10 vref -3.357337e-9
Gw1_11_78 0 sum_h_78 in_11 vref -2.709518e-7
Gw1_12_78 0 sum_h_78 in_12 vref -1.596458e-7
Gw1_13_78 0 sum_h_78 in_13 vref -1.105976e-7
Gw1_14_78 0 sum_h_78 in_14 vref -1.187001e-7
Gw1_15_78 0 sum_h_78 in_15 vref -2.055610e-8
Gw1_16_78 0 sum_h_78 in_16 vref -2.530173e-8
Gw1_17_78 0 sum_h_78 in_17 vref 2.161353e-7
Gw1_18_78 0 sum_h_78 in_18 vref -1.872206e-7
Gw1_19_78 0 sum_h_78 in_19 vref -2.575135e-7
Gw1_20_78 0 sum_h_78 in_20 vref 3.026215e-8
Gw1_21_78 0 sum_h_78 in_21 vref 1.183677e-7
Gw1_22_78 0 sum_h_78 in_22 vref -6.642579e-8
Gw1_23_78 0 sum_h_78 in_23 vref -2.759099e-8
Gw1_24_78 0 sum_h_78 in_24 vref 6.148269e-9
Gw1_25_78 0 sum_h_78 in_25 vref -5.822019e-8
Gw1_26_78 0 sum_h_78 in_26 vref -7.422399e-8
Gw1_27_78 0 sum_h_78 in_27 vref -1.931789e-8
Gw1_28_78 0 sum_h_78 in_28 vref -3.883201e-8
Gw1_29_78 0 sum_h_78 in_29 vref 3.281483e-8
Gw1_30_78 0 sum_h_78 in_30 vref -9.078005e-8
Gw1_31_78 0 sum_h_78 in_31 vref 2.194414e-8
Gw1_32_78 0 sum_h_78 in_32 vref -4.426465e-8
Gw1_33_78 0 sum_h_78 in_33 vref -7.378573e-8
Gw1_34_78 0 sum_h_78 in_34 vref 2.929580e-8
Gw1_35_78 0 sum_h_78 in_35 vref 9.323468e-8
Gw1_36_78 0 sum_h_78 in_36 vref -3.925859e-8
Gw1_37_78 0 sum_h_78 in_37 vref 9.931977e-8
Gw1_38_78 0 sum_h_78 in_38 vref -9.208764e-9
Gw1_39_78 0 sum_h_78 in_39 vref 7.828417e-8
Gw1_40_78 0 sum_h_78 in_40 vref 1.226983e-7
Gw1_41_78 0 sum_h_78 in_41 vref 9.618702e-8
Gw1_42_78 0 sum_h_78 in_42 vref -1.054172e-9
Gw1_43_78 0 sum_h_78 in_43 vref -7.413023e-8
Gw1_44_78 0 sum_h_78 in_44 vref -7.183783e-8
Gw1_45_78 0 sum_h_78 in_45 vref 2.792371e-8
Gw1_46_78 0 sum_h_78 in_46 vref -6.525809e-8
Gw1_47_78 0 sum_h_78 in_47 vref -1.152427e-7
Gw1_48_78 0 sum_h_78 in_48 vref 3.720672e-8
Gw1_0_79 0 sum_h_79 in_0 vref -7.095277e-8
Gw1_1_79 0 sum_h_79 in_1 vref -9.589327e-8
Gw1_2_79 0 sum_h_79 in_2 vref -1.341914e-7
Gw1_3_79 0 sum_h_79 in_3 vref -1.183731e-7
Gw1_4_79 0 sum_h_79 in_4 vref -1.656219e-8
Gw1_5_79 0 sum_h_79 in_5 vref 9.472050e-8
Gw1_6_79 0 sum_h_79 in_6 vref -1.560922e-7
Gw1_7_79 0 sum_h_79 in_7 vref -7.925353e-8
Gw1_8_79 0 sum_h_79 in_8 vref 7.851343e-8
Gw1_9_79 0 sum_h_79 in_9 vref -1.168778e-7
Gw1_10_79 0 sum_h_79 in_10 vref 1.537027e-7
Gw1_11_79 0 sum_h_79 in_11 vref 1.838924e-7
Gw1_12_79 0 sum_h_79 in_12 vref -6.571988e-8
Gw1_13_79 0 sum_h_79 in_13 vref 1.084777e-8
Gw1_14_79 0 sum_h_79 in_14 vref 8.671624e-8
Gw1_15_79 0 sum_h_79 in_15 vref -6.316827e-8
Gw1_16_79 0 sum_h_79 in_16 vref 9.339059e-8
Gw1_17_79 0 sum_h_79 in_17 vref 5.146634e-8
Gw1_18_79 0 sum_h_79 in_18 vref -3.749152e-9
Gw1_19_79 0 sum_h_79 in_19 vref -1.759933e-8
Gw1_20_79 0 sum_h_79 in_20 vref 8.628278e-8
Gw1_21_79 0 sum_h_79 in_21 vref -1.201789e-7
Gw1_22_79 0 sum_h_79 in_22 vref 6.385753e-8
Gw1_23_79 0 sum_h_79 in_23 vref -3.096628e-8
Gw1_24_79 0 sum_h_79 in_24 vref -7.422387e-8
Gw1_25_79 0 sum_h_79 in_25 vref 5.858151e-8
Gw1_26_79 0 sum_h_79 in_26 vref -1.266644e-7
Gw1_27_79 0 sum_h_79 in_27 vref -1.376191e-8
Gw1_28_79 0 sum_h_79 in_28 vref -5.777255e-8
Gw1_29_79 0 sum_h_79 in_29 vref -1.778452e-7
Gw1_30_79 0 sum_h_79 in_30 vref 5.585920e-8
Gw1_31_79 0 sum_h_79 in_31 vref -6.288254e-8
Gw1_32_79 0 sum_h_79 in_32 vref -1.808204e-7
Gw1_33_79 0 sum_h_79 in_33 vref -2.134538e-8
Gw1_34_79 0 sum_h_79 in_34 vref 1.676909e-8
Gw1_35_79 0 sum_h_79 in_35 vref -1.148664e-8
Gw1_36_79 0 sum_h_79 in_36 vref -3.985967e-8
Gw1_37_79 0 sum_h_79 in_37 vref -1.251169e-7
Gw1_38_79 0 sum_h_79 in_38 vref -4.355890e-8
Gw1_39_79 0 sum_h_79 in_39 vref 2.517413e-8
Gw1_40_79 0 sum_h_79 in_40 vref -9.597965e-9
Gw1_41_79 0 sum_h_79 in_41 vref 5.797295e-8
Gw1_42_79 0 sum_h_79 in_42 vref -1.480915e-7
Gw1_43_79 0 sum_h_79 in_43 vref 1.753805e-7
Gw1_44_79 0 sum_h_79 in_44 vref 3.646305e-7
Gw1_45_79 0 sum_h_79 in_45 vref 3.392505e-7
Gw1_46_79 0 sum_h_79 in_46 vref 3.664318e-7
Gw1_47_79 0 sum_h_79 in_47 vref -6.228310e-8
Gw1_48_79 0 sum_h_79 in_48 vref -6.703852e-8
Gw1_0_80 0 sum_h_80 in_0 vref 7.269174e-8
Gw1_1_80 0 sum_h_80 in_1 vref -7.997863e-8
Gw1_2_80 0 sum_h_80 in_2 vref -1.555848e-7
Gw1_3_80 0 sum_h_80 in_3 vref -8.101036e-8
Gw1_4_80 0 sum_h_80 in_4 vref -3.949715e-9
Gw1_5_80 0 sum_h_80 in_5 vref -1.366795e-7
Gw1_6_80 0 sum_h_80 in_6 vref 1.174208e-7
Gw1_7_80 0 sum_h_80 in_7 vref 9.746545e-8
Gw1_8_80 0 sum_h_80 in_8 vref 2.601261e-8
Gw1_9_80 0 sum_h_80 in_9 vref 5.740536e-8
Gw1_10_80 0 sum_h_80 in_10 vref -2.534994e-8
Gw1_11_80 0 sum_h_80 in_11 vref -4.202298e-8
Gw1_12_80 0 sum_h_80 in_12 vref -9.475039e-8
Gw1_13_80 0 sum_h_80 in_13 vref 5.823269e-8
Gw1_14_80 0 sum_h_80 in_14 vref -1.175908e-7
Gw1_15_80 0 sum_h_80 in_15 vref -6.237509e-8
Gw1_16_80 0 sum_h_80 in_16 vref 6.481922e-8
Gw1_17_80 0 sum_h_80 in_17 vref -8.317112e-8
Gw1_18_80 0 sum_h_80 in_18 vref 9.009958e-8
Gw1_19_80 0 sum_h_80 in_19 vref -1.843897e-7
Gw1_20_80 0 sum_h_80 in_20 vref 1.055256e-7
Gw1_21_80 0 sum_h_80 in_21 vref 2.234736e-8
Gw1_22_80 0 sum_h_80 in_22 vref -1.129869e-8
Gw1_23_80 0 sum_h_80 in_23 vref -7.834124e-8
Gw1_24_80 0 sum_h_80 in_24 vref -3.346095e-8
Gw1_25_80 0 sum_h_80 in_25 vref 8.025943e-8
Gw1_26_80 0 sum_h_80 in_26 vref 1.048392e-7
Gw1_27_80 0 sum_h_80 in_27 vref 2.300118e-8
Gw1_28_80 0 sum_h_80 in_28 vref 8.715614e-8
Gw1_29_80 0 sum_h_80 in_29 vref 9.806215e-8
Gw1_30_80 0 sum_h_80 in_30 vref 3.297258e-8
Gw1_31_80 0 sum_h_80 in_31 vref 4.432261e-8
Gw1_32_80 0 sum_h_80 in_32 vref 7.494630e-8
Gw1_33_80 0 sum_h_80 in_33 vref -1.580100e-7
Gw1_34_80 0 sum_h_80 in_34 vref 1.574403e-7
Gw1_35_80 0 sum_h_80 in_35 vref -8.588052e-8
Gw1_36_80 0 sum_h_80 in_36 vref 2.789404e-8
Gw1_37_80 0 sum_h_80 in_37 vref -5.287070e-8
Gw1_38_80 0 sum_h_80 in_38 vref -1.149706e-7
Gw1_39_80 0 sum_h_80 in_39 vref 1.837727e-7
Gw1_40_80 0 sum_h_80 in_40 vref 1.517738e-7
Gw1_41_80 0 sum_h_80 in_41 vref 8.629314e-8
Gw1_42_80 0 sum_h_80 in_42 vref 1.195837e-7
Gw1_43_80 0 sum_h_80 in_43 vref -5.404791e-8
Gw1_44_80 0 sum_h_80 in_44 vref -7.396909e-8
Gw1_45_80 0 sum_h_80 in_45 vref -2.492863e-7
Gw1_46_80 0 sum_h_80 in_46 vref -1.182964e-7
Gw1_47_80 0 sum_h_80 in_47 vref -1.138150e-8
Gw1_48_80 0 sum_h_80 in_48 vref 1.561863e-7
Gw1_0_81 0 sum_h_81 in_0 vref -4.906202e-8
Gw1_1_81 0 sum_h_81 in_1 vref -2.820586e-8
Gw1_2_81 0 sum_h_81 in_2 vref 1.216841e-8
Gw1_3_81 0 sum_h_81 in_3 vref -1.170676e-7
Gw1_4_81 0 sum_h_81 in_4 vref -1.014432e-7
Gw1_5_81 0 sum_h_81 in_5 vref -1.072840e-7
Gw1_6_81 0 sum_h_81 in_6 vref -1.321281e-7
Gw1_7_81 0 sum_h_81 in_7 vref -1.185672e-7
Gw1_8_81 0 sum_h_81 in_8 vref -1.730687e-7
Gw1_9_81 0 sum_h_81 in_9 vref 8.863514e-8
Gw1_10_81 0 sum_h_81 in_10 vref 3.455902e-8
Gw1_11_81 0 sum_h_81 in_11 vref 9.853245e-8
Gw1_12_81 0 sum_h_81 in_12 vref 4.783614e-9
Gw1_13_81 0 sum_h_81 in_13 vref 5.310106e-8
Gw1_14_81 0 sum_h_81 in_14 vref -1.403984e-7
Gw1_15_81 0 sum_h_81 in_15 vref 1.080703e-7
Gw1_16_81 0 sum_h_81 in_16 vref -8.080935e-8
Gw1_17_81 0 sum_h_81 in_17 vref -2.024981e-8
Gw1_18_81 0 sum_h_81 in_18 vref 7.721263e-8
Gw1_19_81 0 sum_h_81 in_19 vref -7.640415e-9
Gw1_20_81 0 sum_h_81 in_20 vref -8.155331e-8
Gw1_21_81 0 sum_h_81 in_21 vref 1.141728e-7
Gw1_22_81 0 sum_h_81 in_22 vref 2.669112e-8
Gw1_23_81 0 sum_h_81 in_23 vref -1.002539e-7
Gw1_24_81 0 sum_h_81 in_24 vref 1.072745e-7
Gw1_25_81 0 sum_h_81 in_25 vref 1.049883e-7
Gw1_26_81 0 sum_h_81 in_26 vref -1.391712e-7
Gw1_27_81 0 sum_h_81 in_27 vref -5.693415e-8
Gw1_28_81 0 sum_h_81 in_28 vref -1.781266e-8
Gw1_29_81 0 sum_h_81 in_29 vref -9.484867e-8
Gw1_30_81 0 sum_h_81 in_30 vref -1.879453e-7
Gw1_31_81 0 sum_h_81 in_31 vref -1.308562e-8
Gw1_32_81 0 sum_h_81 in_32 vref -3.214395e-8
Gw1_33_81 0 sum_h_81 in_33 vref 1.316388e-8
Gw1_34_81 0 sum_h_81 in_34 vref 2.071367e-8
Gw1_35_81 0 sum_h_81 in_35 vref 8.526520e-8
Gw1_36_81 0 sum_h_81 in_36 vref 1.060729e-7
Gw1_37_81 0 sum_h_81 in_37 vref 7.248122e-8
Gw1_38_81 0 sum_h_81 in_38 vref -8.377182e-8
Gw1_39_81 0 sum_h_81 in_39 vref 8.737329e-8
Gw1_40_81 0 sum_h_81 in_40 vref -8.149030e-8
Gw1_41_81 0 sum_h_81 in_41 vref -1.027897e-7
Gw1_42_81 0 sum_h_81 in_42 vref -1.228836e-7
Gw1_43_81 0 sum_h_81 in_43 vref -1.086014e-7
Gw1_44_81 0 sum_h_81 in_44 vref -9.532206e-9
Gw1_45_81 0 sum_h_81 in_45 vref -1.338997e-7
Gw1_46_81 0 sum_h_81 in_46 vref 7.454511e-8
Gw1_47_81 0 sum_h_81 in_47 vref -8.311487e-8
Gw1_48_81 0 sum_h_81 in_48 vref -9.428982e-8
Gw1_0_82 0 sum_h_82 in_0 vref -9.032873e-8
Gw1_1_82 0 sum_h_82 in_1 vref 1.399239e-7
Gw1_2_82 0 sum_h_82 in_2 vref 1.062989e-7
Gw1_3_82 0 sum_h_82 in_3 vref 9.213301e-8
Gw1_4_82 0 sum_h_82 in_4 vref 6.390832e-8
Gw1_5_82 0 sum_h_82 in_5 vref 9.140719e-8
Gw1_6_82 0 sum_h_82 in_6 vref -3.313044e-8
Gw1_7_82 0 sum_h_82 in_7 vref 6.859354e-8
Gw1_8_82 0 sum_h_82 in_8 vref 4.887943e-8
Gw1_9_82 0 sum_h_82 in_9 vref 5.972394e-8
Gw1_10_82 0 sum_h_82 in_10 vref 6.896727e-8
Gw1_11_82 0 sum_h_82 in_11 vref -2.016783e-7
Gw1_12_82 0 sum_h_82 in_12 vref -2.293712e-8
Gw1_13_82 0 sum_h_82 in_13 vref -1.218390e-7
Gw1_14_82 0 sum_h_82 in_14 vref 1.065122e-7
Gw1_15_82 0 sum_h_82 in_15 vref 9.983491e-8
Gw1_16_82 0 sum_h_82 in_16 vref 7.901404e-8
Gw1_17_82 0 sum_h_82 in_17 vref -1.038626e-7
Gw1_18_82 0 sum_h_82 in_18 vref -1.136964e-7
Gw1_19_82 0 sum_h_82 in_19 vref 1.292099e-7
Gw1_20_82 0 sum_h_82 in_20 vref 2.529492e-8
Gw1_21_82 0 sum_h_82 in_21 vref -6.819908e-8
Gw1_22_82 0 sum_h_82 in_22 vref 9.627010e-8
Gw1_23_82 0 sum_h_82 in_23 vref 1.731701e-8
Gw1_24_82 0 sum_h_82 in_24 vref 4.646367e-9
Gw1_25_82 0 sum_h_82 in_25 vref 1.049903e-7
Gw1_26_82 0 sum_h_82 in_26 vref 1.216447e-7
Gw1_27_82 0 sum_h_82 in_27 vref 1.566535e-7
Gw1_28_82 0 sum_h_82 in_28 vref -6.516504e-9
Gw1_29_82 0 sum_h_82 in_29 vref 4.003729e-8
Gw1_30_82 0 sum_h_82 in_30 vref -1.521730e-7
Gw1_31_82 0 sum_h_82 in_31 vref 1.441931e-7
Gw1_32_82 0 sum_h_82 in_32 vref 6.470481e-8
Gw1_33_82 0 sum_h_82 in_33 vref 1.180620e-8
Gw1_34_82 0 sum_h_82 in_34 vref -2.280983e-8
Gw1_35_82 0 sum_h_82 in_35 vref -1.047233e-7
Gw1_36_82 0 sum_h_82 in_36 vref -5.774412e-8
Gw1_37_82 0 sum_h_82 in_37 vref -1.415857e-7
Gw1_38_82 0 sum_h_82 in_38 vref 7.732771e-8
Gw1_39_82 0 sum_h_82 in_39 vref -2.987811e-8
Gw1_40_82 0 sum_h_82 in_40 vref -4.655866e-8
Gw1_41_82 0 sum_h_82 in_41 vref -7.995236e-9
Gw1_42_82 0 sum_h_82 in_42 vref -4.826570e-8
Gw1_43_82 0 sum_h_82 in_43 vref -9.718254e-8
Gw1_44_82 0 sum_h_82 in_44 vref -1.127602e-7
Gw1_45_82 0 sum_h_82 in_45 vref -2.433264e-8
Gw1_46_82 0 sum_h_82 in_46 vref 6.194583e-8
Gw1_47_82 0 sum_h_82 in_47 vref -5.225089e-8
Gw1_48_82 0 sum_h_82 in_48 vref -2.272975e-8
Gw1_0_83 0 sum_h_83 in_0 vref -5.441081e-8
Gw1_1_83 0 sum_h_83 in_1 vref 1.626652e-8
Gw1_2_83 0 sum_h_83 in_2 vref 1.330241e-7
Gw1_3_83 0 sum_h_83 in_3 vref 2.050670e-7
Gw1_4_83 0 sum_h_83 in_4 vref 5.033156e-8
Gw1_5_83 0 sum_h_83 in_5 vref -5.331739e-8
Gw1_6_83 0 sum_h_83 in_6 vref -4.218582e-8
Gw1_7_83 0 sum_h_83 in_7 vref 1.022168e-7
Gw1_8_83 0 sum_h_83 in_8 vref 4.337320e-8
Gw1_9_83 0 sum_h_83 in_9 vref -7.188164e-8
Gw1_10_83 0 sum_h_83 in_10 vref 5.810983e-8
Gw1_11_83 0 sum_h_83 in_11 vref -3.666092e-8
Gw1_12_83 0 sum_h_83 in_12 vref -1.170334e-7
Gw1_13_83 0 sum_h_83 in_13 vref 7.931943e-8
Gw1_14_83 0 sum_h_83 in_14 vref -4.707962e-8
Gw1_15_83 0 sum_h_83 in_15 vref -1.489840e-7
Gw1_16_83 0 sum_h_83 in_16 vref -1.049278e-7
Gw1_17_83 0 sum_h_83 in_17 vref -1.346551e-7
Gw1_18_83 0 sum_h_83 in_18 vref -2.025521e-7
Gw1_19_83 0 sum_h_83 in_19 vref -1.080769e-8
Gw1_20_83 0 sum_h_83 in_20 vref -4.092161e-8
Gw1_21_83 0 sum_h_83 in_21 vref -2.402779e-8
Gw1_22_83 0 sum_h_83 in_22 vref -2.946231e-8
Gw1_23_83 0 sum_h_83 in_23 vref -1.423435e-8
Gw1_24_83 0 sum_h_83 in_24 vref 2.060212e-7
Gw1_25_83 0 sum_h_83 in_25 vref -7.451924e-9
Gw1_26_83 0 sum_h_83 in_26 vref 6.187423e-8
Gw1_27_83 0 sum_h_83 in_27 vref 4.447115e-9
Gw1_28_83 0 sum_h_83 in_28 vref -1.079860e-7
Gw1_29_83 0 sum_h_83 in_29 vref 7.900897e-8
Gw1_30_83 0 sum_h_83 in_30 vref 1.459614e-7
Gw1_31_83 0 sum_h_83 in_31 vref 1.103366e-8
Gw1_32_83 0 sum_h_83 in_32 vref -1.049282e-9
Gw1_33_83 0 sum_h_83 in_33 vref 2.923735e-8
Gw1_34_83 0 sum_h_83 in_34 vref 2.673215e-7
Gw1_35_83 0 sum_h_83 in_35 vref -1.165347e-7
Gw1_36_83 0 sum_h_83 in_36 vref 3.929392e-9
Gw1_37_83 0 sum_h_83 in_37 vref -9.817462e-9
Gw1_38_83 0 sum_h_83 in_38 vref -1.110491e-9
Gw1_39_83 0 sum_h_83 in_39 vref -5.849931e-9
Gw1_40_83 0 sum_h_83 in_40 vref 3.536097e-8
Gw1_41_83 0 sum_h_83 in_41 vref 4.169875e-8
Gw1_42_83 0 sum_h_83 in_42 vref -1.205385e-7
Gw1_43_83 0 sum_h_83 in_43 vref -1.295765e-8
Gw1_44_83 0 sum_h_83 in_44 vref -2.353683e-7
Gw1_45_83 0 sum_h_83 in_45 vref -2.235567e-7
Gw1_46_83 0 sum_h_83 in_46 vref -1.503362e-7
Gw1_47_83 0 sum_h_83 in_47 vref 4.751579e-8
Gw1_48_83 0 sum_h_83 in_48 vref -1.238850e-7
Gw1_0_84 0 sum_h_84 in_0 vref -1.203330e-7
Gw1_1_84 0 sum_h_84 in_1 vref -1.083156e-7
Gw1_2_84 0 sum_h_84 in_2 vref 2.696937e-8
Gw1_3_84 0 sum_h_84 in_3 vref 1.488327e-8
Gw1_4_84 0 sum_h_84 in_4 vref 6.552476e-8
Gw1_5_84 0 sum_h_84 in_5 vref -7.464934e-8
Gw1_6_84 0 sum_h_84 in_6 vref 1.284315e-7
Gw1_7_84 0 sum_h_84 in_7 vref 1.234645e-7
Gw1_8_84 0 sum_h_84 in_8 vref 9.340329e-8
Gw1_9_84 0 sum_h_84 in_9 vref -1.912072e-8
Gw1_10_84 0 sum_h_84 in_10 vref 9.391006e-8
Gw1_11_84 0 sum_h_84 in_11 vref -1.386809e-7
Gw1_12_84 0 sum_h_84 in_12 vref 1.884674e-7
Gw1_13_84 0 sum_h_84 in_13 vref 1.470887e-7
Gw1_14_84 0 sum_h_84 in_14 vref 7.416268e-8
Gw1_15_84 0 sum_h_84 in_15 vref 8.222820e-8
Gw1_16_84 0 sum_h_84 in_16 vref 7.428679e-8
Gw1_17_84 0 sum_h_84 in_17 vref -1.245549e-8
Gw1_18_84 0 sum_h_84 in_18 vref 1.156638e-7
Gw1_19_84 0 sum_h_84 in_19 vref 9.329698e-8
Gw1_20_84 0 sum_h_84 in_20 vref -1.007814e-7
Gw1_21_84 0 sum_h_84 in_21 vref -1.328943e-7
Gw1_22_84 0 sum_h_84 in_22 vref -5.406758e-8
Gw1_23_84 0 sum_h_84 in_23 vref -4.795895e-8
Gw1_24_84 0 sum_h_84 in_24 vref 5.258720e-8
Gw1_25_84 0 sum_h_84 in_25 vref 1.039384e-7
Gw1_26_84 0 sum_h_84 in_26 vref 7.877957e-8
Gw1_27_84 0 sum_h_84 in_27 vref -1.007330e-7
Gw1_28_84 0 sum_h_84 in_28 vref -5.436591e-8
Gw1_29_84 0 sum_h_84 in_29 vref -5.007001e-8
Gw1_30_84 0 sum_h_84 in_30 vref -1.137391e-7
Gw1_31_84 0 sum_h_84 in_31 vref 1.173939e-8
Gw1_32_84 0 sum_h_84 in_32 vref -1.432017e-8
Gw1_33_84 0 sum_h_84 in_33 vref -1.341611e-7
Gw1_34_84 0 sum_h_84 in_34 vref -9.813372e-9
Gw1_35_84 0 sum_h_84 in_35 vref 9.294786e-8
Gw1_36_84 0 sum_h_84 in_36 vref 7.150432e-8
Gw1_37_84 0 sum_h_84 in_37 vref -4.648376e-9
Gw1_38_84 0 sum_h_84 in_38 vref -8.182367e-8
Gw1_39_84 0 sum_h_84 in_39 vref -7.804231e-8
Gw1_40_84 0 sum_h_84 in_40 vref 9.964869e-8
Gw1_41_84 0 sum_h_84 in_41 vref -1.322001e-7
Gw1_42_84 0 sum_h_84 in_42 vref 1.371900e-7
Gw1_43_84 0 sum_h_84 in_43 vref -2.262581e-8
Gw1_44_84 0 sum_h_84 in_44 vref 1.451014e-7
Gw1_45_84 0 sum_h_84 in_45 vref -1.500052e-7
Gw1_46_84 0 sum_h_84 in_46 vref 2.262420e-8
Gw1_47_84 0 sum_h_84 in_47 vref 6.838044e-8
Gw1_48_84 0 sum_h_84 in_48 vref 5.454064e-8
Gw1_0_85 0 sum_h_85 in_0 vref -1.802923e-8
Gw1_1_85 0 sum_h_85 in_1 vref 1.536525e-8
Gw1_2_85 0 sum_h_85 in_2 vref 4.386456e-8
Gw1_3_85 0 sum_h_85 in_3 vref 1.358501e-8
Gw1_4_85 0 sum_h_85 in_4 vref -1.052785e-7
Gw1_5_85 0 sum_h_85 in_5 vref -1.070019e-7
Gw1_6_85 0 sum_h_85 in_6 vref 1.358815e-7
Gw1_7_85 0 sum_h_85 in_7 vref 1.373643e-9
Gw1_8_85 0 sum_h_85 in_8 vref -1.179420e-7
Gw1_9_85 0 sum_h_85 in_9 vref -1.809902e-7
Gw1_10_85 0 sum_h_85 in_10 vref -1.472093e-7
Gw1_11_85 0 sum_h_85 in_11 vref 2.703861e-8
Gw1_12_85 0 sum_h_85 in_12 vref -1.045990e-9
Gw1_13_85 0 sum_h_85 in_13 vref 5.395746e-8
Gw1_14_85 0 sum_h_85 in_14 vref -9.175043e-8
Gw1_15_85 0 sum_h_85 in_15 vref -1.469603e-7
Gw1_16_85 0 sum_h_85 in_16 vref -1.342021e-7
Gw1_17_85 0 sum_h_85 in_17 vref 9.800949e-8
Gw1_18_85 0 sum_h_85 in_18 vref 3.554467e-8
Gw1_19_85 0 sum_h_85 in_19 vref 1.142805e-7
Gw1_20_85 0 sum_h_85 in_20 vref 9.941319e-8
Gw1_21_85 0 sum_h_85 in_21 vref 7.759047e-8
Gw1_22_85 0 sum_h_85 in_22 vref 3.574873e-8
Gw1_23_85 0 sum_h_85 in_23 vref -3.651210e-8
Gw1_24_85 0 sum_h_85 in_24 vref 1.141442e-7
Gw1_25_85 0 sum_h_85 in_25 vref 4.163032e-8
Gw1_26_85 0 sum_h_85 in_26 vref -7.709944e-9
Gw1_27_85 0 sum_h_85 in_27 vref 1.200410e-7
Gw1_28_85 0 sum_h_85 in_28 vref 3.982798e-8
Gw1_29_85 0 sum_h_85 in_29 vref 1.650687e-7
Gw1_30_85 0 sum_h_85 in_30 vref -1.597307e-7
Gw1_31_85 0 sum_h_85 in_31 vref -7.298115e-8
Gw1_32_85 0 sum_h_85 in_32 vref -1.297851e-8
Gw1_33_85 0 sum_h_85 in_33 vref -3.736611e-8
Gw1_34_85 0 sum_h_85 in_34 vref 1.403158e-7
Gw1_35_85 0 sum_h_85 in_35 vref 1.535417e-8
Gw1_36_85 0 sum_h_85 in_36 vref -8.897259e-8
Gw1_37_85 0 sum_h_85 in_37 vref 1.633149e-8
Gw1_38_85 0 sum_h_85 in_38 vref 4.108150e-8
Gw1_39_85 0 sum_h_85 in_39 vref -1.542985e-7
Gw1_40_85 0 sum_h_85 in_40 vref 2.956479e-8
Gw1_41_85 0 sum_h_85 in_41 vref -2.560580e-8
Gw1_42_85 0 sum_h_85 in_42 vref -8.534214e-8
Gw1_43_85 0 sum_h_85 in_43 vref 1.718540e-8
Gw1_44_85 0 sum_h_85 in_44 vref 2.478676e-8
Gw1_45_85 0 sum_h_85 in_45 vref -5.941307e-8
Gw1_46_85 0 sum_h_85 in_46 vref -1.000201e-7
Gw1_47_85 0 sum_h_85 in_47 vref -4.218142e-8
Gw1_48_85 0 sum_h_85 in_48 vref 6.432415e-8
Gw1_0_86 0 sum_h_86 in_0 vref -6.011756e-8
Gw1_1_86 0 sum_h_86 in_1 vref -1.280938e-7
Gw1_2_86 0 sum_h_86 in_2 vref -3.816715e-8
Gw1_3_86 0 sum_h_86 in_3 vref -2.621468e-7
Gw1_4_86 0 sum_h_86 in_4 vref 2.355614e-7
Gw1_5_86 0 sum_h_86 in_5 vref 8.786471e-8
Gw1_6_86 0 sum_h_86 in_6 vref 3.533797e-9
Gw1_7_86 0 sum_h_86 in_7 vref 1.101424e-7
Gw1_8_86 0 sum_h_86 in_8 vref 7.369279e-8
Gw1_9_86 0 sum_h_86 in_9 vref -3.501652e-7
Gw1_10_86 0 sum_h_86 in_10 vref 9.635798e-10
Gw1_11_86 0 sum_h_86 in_11 vref 1.752765e-8
Gw1_12_86 0 sum_h_86 in_12 vref 1.013412e-7
Gw1_13_86 0 sum_h_86 in_13 vref 7.530304e-8
Gw1_14_86 0 sum_h_86 in_14 vref -1.419010e-7
Gw1_15_86 0 sum_h_86 in_15 vref 5.449328e-8
Gw1_16_86 0 sum_h_86 in_16 vref -1.722071e-7
Gw1_17_86 0 sum_h_86 in_17 vref 8.037135e-8
Gw1_18_86 0 sum_h_86 in_18 vref -1.383621e-7
Gw1_19_86 0 sum_h_86 in_19 vref -1.510121e-7
Gw1_20_86 0 sum_h_86 in_20 vref -3.411104e-8
Gw1_21_86 0 sum_h_86 in_21 vref 5.584536e-8
Gw1_22_86 0 sum_h_86 in_22 vref -8.956972e-8
Gw1_23_86 0 sum_h_86 in_23 vref 8.990714e-8
Gw1_24_86 0 sum_h_86 in_24 vref 3.222141e-8
Gw1_25_86 0 sum_h_86 in_25 vref -4.342846e-8
Gw1_26_86 0 sum_h_86 in_26 vref 7.165846e-8
Gw1_27_86 0 sum_h_86 in_27 vref -1.153884e-7
Gw1_28_86 0 sum_h_86 in_28 vref 1.024758e-7
Gw1_29_86 0 sum_h_86 in_29 vref 8.408345e-8
Gw1_30_86 0 sum_h_86 in_30 vref 8.890233e-9
Gw1_31_86 0 sum_h_86 in_31 vref -9.515411e-8
Gw1_32_86 0 sum_h_86 in_32 vref 9.108969e-8
Gw1_33_86 0 sum_h_86 in_33 vref -7.636959e-10
Gw1_34_86 0 sum_h_86 in_34 vref -2.265918e-8
Gw1_35_86 0 sum_h_86 in_35 vref 1.498614e-8
Gw1_36_86 0 sum_h_86 in_36 vref 2.994366e-9
Gw1_37_86 0 sum_h_86 in_37 vref 6.547932e-8
Gw1_38_86 0 sum_h_86 in_38 vref 3.793167e-8
Gw1_39_86 0 sum_h_86 in_39 vref -2.629111e-8
Gw1_40_86 0 sum_h_86 in_40 vref 9.476555e-8
Gw1_41_86 0 sum_h_86 in_41 vref -8.643673e-8
Gw1_42_86 0 sum_h_86 in_42 vref 5.369658e-8
Gw1_43_86 0 sum_h_86 in_43 vref -7.391252e-8
Gw1_44_86 0 sum_h_86 in_44 vref -1.417899e-7
Gw1_45_86 0 sum_h_86 in_45 vref -1.309290e-7
Gw1_46_86 0 sum_h_86 in_46 vref -1.143403e-7
Gw1_47_86 0 sum_h_86 in_47 vref 7.364684e-8
Gw1_48_86 0 sum_h_86 in_48 vref 1.269473e-7
Gw1_0_87 0 sum_h_87 in_0 vref -3.952118e-8
Gw1_1_87 0 sum_h_87 in_1 vref -2.532504e-8
Gw1_2_87 0 sum_h_87 in_2 vref -1.432516e-7
Gw1_3_87 0 sum_h_87 in_3 vref 1.171531e-7
Gw1_4_87 0 sum_h_87 in_4 vref 9.614411e-8
Gw1_5_87 0 sum_h_87 in_5 vref -4.224186e-8
Gw1_6_87 0 sum_h_87 in_6 vref -1.897745e-8
Gw1_7_87 0 sum_h_87 in_7 vref 6.723387e-9
Gw1_8_87 0 sum_h_87 in_8 vref -1.554109e-7
Gw1_9_87 0 sum_h_87 in_9 vref 9.929818e-8
Gw1_10_87 0 sum_h_87 in_10 vref 1.806749e-7
Gw1_11_87 0 sum_h_87 in_11 vref -3.753909e-8
Gw1_12_87 0 sum_h_87 in_12 vref -7.386477e-9
Gw1_13_87 0 sum_h_87 in_13 vref 1.034479e-7
Gw1_14_87 0 sum_h_87 in_14 vref -4.884098e-8
Gw1_15_87 0 sum_h_87 in_15 vref 2.394849e-8
Gw1_16_87 0 sum_h_87 in_16 vref -4.376278e-8
Gw1_17_87 0 sum_h_87 in_17 vref -1.153864e-7
Gw1_18_87 0 sum_h_87 in_18 vref -1.300674e-7
Gw1_19_87 0 sum_h_87 in_19 vref -1.814198e-7
Gw1_20_87 0 sum_h_87 in_20 vref -8.134358e-8
Gw1_21_87 0 sum_h_87 in_21 vref -2.374771e-9
Gw1_22_87 0 sum_h_87 in_22 vref 1.367057e-8
Gw1_23_87 0 sum_h_87 in_23 vref -2.495115e-7
Gw1_24_87 0 sum_h_87 in_24 vref -1.421438e-7
Gw1_25_87 0 sum_h_87 in_25 vref -7.455394e-8
Gw1_26_87 0 sum_h_87 in_26 vref 9.117934e-8
Gw1_27_87 0 sum_h_87 in_27 vref 1.283817e-8
Gw1_28_87 0 sum_h_87 in_28 vref -1.124840e-7
Gw1_29_87 0 sum_h_87 in_29 vref -3.653215e-8
Gw1_30_87 0 sum_h_87 in_30 vref -1.988907e-8
Gw1_31_87 0 sum_h_87 in_31 vref 6.400452e-8
Gw1_32_87 0 sum_h_87 in_32 vref 4.952775e-8
Gw1_33_87 0 sum_h_87 in_33 vref 7.601861e-8
Gw1_34_87 0 sum_h_87 in_34 vref -8.683563e-10
Gw1_35_87 0 sum_h_87 in_35 vref 8.397416e-8
Gw1_36_87 0 sum_h_87 in_36 vref 1.321672e-7
Gw1_37_87 0 sum_h_87 in_37 vref 7.391437e-8
Gw1_38_87 0 sum_h_87 in_38 vref -1.168457e-7
Gw1_39_87 0 sum_h_87 in_39 vref 2.619089e-8
Gw1_40_87 0 sum_h_87 in_40 vref 6.102825e-8
Gw1_41_87 0 sum_h_87 in_41 vref -4.896579e-8
Gw1_42_87 0 sum_h_87 in_42 vref -6.510200e-8
Gw1_43_87 0 sum_h_87 in_43 vref -3.717430e-8
Gw1_44_87 0 sum_h_87 in_44 vref 5.186917e-8
Gw1_45_87 0 sum_h_87 in_45 vref -1.885839e-7
Gw1_46_87 0 sum_h_87 in_46 vref -9.059309e-8
Gw1_47_87 0 sum_h_87 in_47 vref 2.555789e-8
Gw1_48_87 0 sum_h_87 in_48 vref -1.905830e-8
Gw1_0_88 0 sum_h_88 in_0 vref -2.390473e-8
Gw1_1_88 0 sum_h_88 in_1 vref -4.331227e-8
Gw1_2_88 0 sum_h_88 in_2 vref 6.531246e-8
Gw1_3_88 0 sum_h_88 in_3 vref -1.150147e-7
Gw1_4_88 0 sum_h_88 in_4 vref -8.610195e-8
Gw1_5_88 0 sum_h_88 in_5 vref -8.521037e-9
Gw1_6_88 0 sum_h_88 in_6 vref 3.683257e-8
Gw1_7_88 0 sum_h_88 in_7 vref -5.918465e-8
Gw1_8_88 0 sum_h_88 in_8 vref -4.683957e-8
Gw1_9_88 0 sum_h_88 in_9 vref 1.048719e-7
Gw1_10_88 0 sum_h_88 in_10 vref 9.820145e-8
Gw1_11_88 0 sum_h_88 in_11 vref 1.230966e-7
Gw1_12_88 0 sum_h_88 in_12 vref 7.514571e-8
Gw1_13_88 0 sum_h_88 in_13 vref -1.880655e-7
Gw1_14_88 0 sum_h_88 in_14 vref 5.475851e-8
Gw1_15_88 0 sum_h_88 in_15 vref -1.258035e-7
Gw1_16_88 0 sum_h_88 in_16 vref 1.474848e-8
Gw1_17_88 0 sum_h_88 in_17 vref 5.215874e-8
Gw1_18_88 0 sum_h_88 in_18 vref 2.666384e-8
Gw1_19_88 0 sum_h_88 in_19 vref 1.079735e-7
Gw1_20_88 0 sum_h_88 in_20 vref -7.611391e-8
Gw1_21_88 0 sum_h_88 in_21 vref -1.539205e-7
Gw1_22_88 0 sum_h_88 in_22 vref 9.376572e-9
Gw1_23_88 0 sum_h_88 in_23 vref 8.910101e-8
Gw1_24_88 0 sum_h_88 in_24 vref -1.550922e-7
Gw1_25_88 0 sum_h_88 in_25 vref -1.530079e-7
Gw1_26_88 0 sum_h_88 in_26 vref -2.036337e-8
Gw1_27_88 0 sum_h_88 in_27 vref -7.829625e-8
Gw1_28_88 0 sum_h_88 in_28 vref 4.074526e-8
Gw1_29_88 0 sum_h_88 in_29 vref -1.271485e-7
Gw1_30_88 0 sum_h_88 in_30 vref -1.124894e-7
Gw1_31_88 0 sum_h_88 in_31 vref -2.258054e-7
Gw1_32_88 0 sum_h_88 in_32 vref -4.103185e-8
Gw1_33_88 0 sum_h_88 in_33 vref 9.432429e-8
Gw1_34_88 0 sum_h_88 in_34 vref -6.950866e-8
Gw1_35_88 0 sum_h_88 in_35 vref -1.113189e-7
Gw1_36_88 0 sum_h_88 in_36 vref -5.730526e-8
Gw1_37_88 0 sum_h_88 in_37 vref 1.693336e-8
Gw1_38_88 0 sum_h_88 in_38 vref 8.586989e-8
Gw1_39_88 0 sum_h_88 in_39 vref -5.217630e-8
Gw1_40_88 0 sum_h_88 in_40 vref -8.174354e-8
Gw1_41_88 0 sum_h_88 in_41 vref -1.316464e-7
Gw1_42_88 0 sum_h_88 in_42 vref -4.683573e-8
Gw1_43_88 0 sum_h_88 in_43 vref -5.195669e-8
Gw1_44_88 0 sum_h_88 in_44 vref 2.172455e-7
Gw1_45_88 0 sum_h_88 in_45 vref 1.627775e-8
Gw1_46_88 0 sum_h_88 in_46 vref 1.298774e-8
Gw1_47_88 0 sum_h_88 in_47 vref 3.111032e-8
Gw1_48_88 0 sum_h_88 in_48 vref -6.974184e-8
Gw1_0_89 0 sum_h_89 in_0 vref 3.637131e-8
Gw1_1_89 0 sum_h_89 in_1 vref -5.569900e-8
Gw1_2_89 0 sum_h_89 in_2 vref 9.478770e-8
Gw1_3_89 0 sum_h_89 in_3 vref 1.687853e-8
Gw1_4_89 0 sum_h_89 in_4 vref -8.025262e-8
Gw1_5_89 0 sum_h_89 in_5 vref 3.948273e-8
Gw1_6_89 0 sum_h_89 in_6 vref 8.631479e-8
Gw1_7_89 0 sum_h_89 in_7 vref -6.929952e-8
Gw1_8_89 0 sum_h_89 in_8 vref 3.021389e-8
Gw1_9_89 0 sum_h_89 in_9 vref 1.484106e-7
Gw1_10_89 0 sum_h_89 in_10 vref -2.142250e-7
Gw1_11_89 0 sum_h_89 in_11 vref 4.746104e-8
Gw1_12_89 0 sum_h_89 in_12 vref 7.210975e-8
Gw1_13_89 0 sum_h_89 in_13 vref -7.968697e-8
Gw1_14_89 0 sum_h_89 in_14 vref -1.370512e-8
Gw1_15_89 0 sum_h_89 in_15 vref 2.964511e-8
Gw1_16_89 0 sum_h_89 in_16 vref 1.363007e-7
Gw1_17_89 0 sum_h_89 in_17 vref -2.208007e-7
Gw1_18_89 0 sum_h_89 in_18 vref 1.697927e-7
Gw1_19_89 0 sum_h_89 in_19 vref 1.477859e-8
Gw1_20_89 0 sum_h_89 in_20 vref -1.281589e-7
Gw1_21_89 0 sum_h_89 in_21 vref -3.320178e-8
Gw1_22_89 0 sum_h_89 in_22 vref 1.910513e-7
Gw1_23_89 0 sum_h_89 in_23 vref -1.414465e-7
Gw1_24_89 0 sum_h_89 in_24 vref -1.678680e-8
Gw1_25_89 0 sum_h_89 in_25 vref 5.408310e-8
Gw1_26_89 0 sum_h_89 in_26 vref 5.938348e-8
Gw1_27_89 0 sum_h_89 in_27 vref 3.855743e-8
Gw1_28_89 0 sum_h_89 in_28 vref 3.608333e-8
Gw1_29_89 0 sum_h_89 in_29 vref -2.782095e-8
Gw1_30_89 0 sum_h_89 in_30 vref 1.617263e-8
Gw1_31_89 0 sum_h_89 in_31 vref -6.957973e-8
Gw1_32_89 0 sum_h_89 in_32 vref -1.548569e-8
Gw1_33_89 0 sum_h_89 in_33 vref -6.532287e-8
Gw1_34_89 0 sum_h_89 in_34 vref 4.583229e-8
Gw1_35_89 0 sum_h_89 in_35 vref -1.287020e-7
Gw1_36_89 0 sum_h_89 in_36 vref 9.472500e-8
Gw1_37_89 0 sum_h_89 in_37 vref -1.482298e-8
Gw1_38_89 0 sum_h_89 in_38 vref 1.226469e-7
Gw1_39_89 0 sum_h_89 in_39 vref -1.624892e-7
Gw1_40_89 0 sum_h_89 in_40 vref -2.503892e-8
Gw1_41_89 0 sum_h_89 in_41 vref 6.598092e-8
Gw1_42_89 0 sum_h_89 in_42 vref -1.140238e-7
Gw1_43_89 0 sum_h_89 in_43 vref 1.288167e-7
Gw1_44_89 0 sum_h_89 in_44 vref -8.976392e-8
Gw1_45_89 0 sum_h_89 in_45 vref 1.329403e-7
Gw1_46_89 0 sum_h_89 in_46 vref -2.337294e-9
Gw1_47_89 0 sum_h_89 in_47 vref -9.212653e-8
Gw1_48_89 0 sum_h_89 in_48 vref -7.111568e-9
Gw1_0_90 0 sum_h_90 in_0 vref 9.763330e-8
Gw1_1_90 0 sum_h_90 in_1 vref 3.228195e-8
Gw1_2_90 0 sum_h_90 in_2 vref -9.088016e-8
Gw1_3_90 0 sum_h_90 in_3 vref 2.427876e-8
Gw1_4_90 0 sum_h_90 in_4 vref 7.802243e-8
Gw1_5_90 0 sum_h_90 in_5 vref 2.777455e-8
Gw1_6_90 0 sum_h_90 in_6 vref 1.241894e-8
Gw1_7_90 0 sum_h_90 in_7 vref -1.139637e-7
Gw1_8_90 0 sum_h_90 in_8 vref 6.663065e-8
Gw1_9_90 0 sum_h_90 in_9 vref -3.118295e-8
Gw1_10_90 0 sum_h_90 in_10 vref 5.722488e-8
Gw1_11_90 0 sum_h_90 in_11 vref -4.520946e-8
Gw1_12_90 0 sum_h_90 in_12 vref -3.427401e-9
Gw1_13_90 0 sum_h_90 in_13 vref -1.811784e-8
Gw1_14_90 0 sum_h_90 in_14 vref -1.214304e-7
Gw1_15_90 0 sum_h_90 in_15 vref -1.384337e-7
Gw1_16_90 0 sum_h_90 in_16 vref -3.584178e-8
Gw1_17_90 0 sum_h_90 in_17 vref 9.537201e-8
Gw1_18_90 0 sum_h_90 in_18 vref 5.307743e-8
Gw1_19_90 0 sum_h_90 in_19 vref 1.866369e-7
Gw1_20_90 0 sum_h_90 in_20 vref 1.342254e-7
Gw1_21_90 0 sum_h_90 in_21 vref -4.740620e-8
Gw1_22_90 0 sum_h_90 in_22 vref -3.060117e-8
Gw1_23_90 0 sum_h_90 in_23 vref 1.248473e-8
Gw1_24_90 0 sum_h_90 in_24 vref -9.087454e-8
Gw1_25_90 0 sum_h_90 in_25 vref -1.758355e-7
Gw1_26_90 0 sum_h_90 in_26 vref -2.846692e-7
Gw1_27_90 0 sum_h_90 in_27 vref -1.198448e-7
Gw1_28_90 0 sum_h_90 in_28 vref -1.169262e-7
Gw1_29_90 0 sum_h_90 in_29 vref -4.414436e-8
Gw1_30_90 0 sum_h_90 in_30 vref 6.415058e-8
Gw1_31_90 0 sum_h_90 in_31 vref 4.384073e-9
Gw1_32_90 0 sum_h_90 in_32 vref -7.011143e-8
Gw1_33_90 0 sum_h_90 in_33 vref -2.035172e-7
Gw1_34_90 0 sum_h_90 in_34 vref -5.690250e-8
Gw1_35_90 0 sum_h_90 in_35 vref 5.131032e-8
Gw1_36_90 0 sum_h_90 in_36 vref 9.721242e-8
Gw1_37_90 0 sum_h_90 in_37 vref 2.908991e-8
Gw1_38_90 0 sum_h_90 in_38 vref 6.384624e-8
Gw1_39_90 0 sum_h_90 in_39 vref 4.426620e-8
Gw1_40_90 0 sum_h_90 in_40 vref -7.839638e-8
Gw1_41_90 0 sum_h_90 in_41 vref 7.856521e-8
Gw1_42_90 0 sum_h_90 in_42 vref -1.514826e-7
Gw1_43_90 0 sum_h_90 in_43 vref 1.321901e-7
Gw1_44_90 0 sum_h_90 in_44 vref 2.131341e-7
Gw1_45_90 0 sum_h_90 in_45 vref 1.122551e-7
Gw1_46_90 0 sum_h_90 in_46 vref 1.282050e-7
Gw1_47_90 0 sum_h_90 in_47 vref -8.316417e-8
Gw1_48_90 0 sum_h_90 in_48 vref 9.888551e-8
Gw1_0_91 0 sum_h_91 in_0 vref -7.896728e-8
Gw1_1_91 0 sum_h_91 in_1 vref 2.728374e-8
Gw1_2_91 0 sum_h_91 in_2 vref -1.420390e-9
Gw1_3_91 0 sum_h_91 in_3 vref 1.156301e-7
Gw1_4_91 0 sum_h_91 in_4 vref -6.952548e-8
Gw1_5_91 0 sum_h_91 in_5 vref 3.284797e-8
Gw1_6_91 0 sum_h_91 in_6 vref 6.272246e-8
Gw1_7_91 0 sum_h_91 in_7 vref -5.442957e-8
Gw1_8_91 0 sum_h_91 in_8 vref -5.014630e-8
Gw1_9_91 0 sum_h_91 in_9 vref 4.317277e-8
Gw1_10_91 0 sum_h_91 in_10 vref 1.316163e-7
Gw1_11_91 0 sum_h_91 in_11 vref -3.101314e-7
Gw1_12_91 0 sum_h_91 in_12 vref 5.437068e-8
Gw1_13_91 0 sum_h_91 in_13 vref 1.734104e-8
Gw1_14_91 0 sum_h_91 in_14 vref 3.132879e-8
Gw1_15_91 0 sum_h_91 in_15 vref -2.353545e-7
Gw1_16_91 0 sum_h_91 in_16 vref 3.507669e-9
Gw1_17_91 0 sum_h_91 in_17 vref -1.094061e-7
Gw1_18_91 0 sum_h_91 in_18 vref -1.462413e-8
Gw1_19_91 0 sum_h_91 in_19 vref 2.618586e-7
Gw1_20_91 0 sum_h_91 in_20 vref -1.367259e-7
Gw1_21_91 0 sum_h_91 in_21 vref -9.189998e-8
Gw1_22_91 0 sum_h_91 in_22 vref -1.325808e-7
Gw1_23_91 0 sum_h_91 in_23 vref 5.997376e-8
Gw1_24_91 0 sum_h_91 in_24 vref 6.535542e-8
Gw1_25_91 0 sum_h_91 in_25 vref 7.083486e-8
Gw1_26_91 0 sum_h_91 in_26 vref 2.753505e-8
Gw1_27_91 0 sum_h_91 in_27 vref 5.761743e-8
Gw1_28_91 0 sum_h_91 in_28 vref 1.182557e-7
Gw1_29_91 0 sum_h_91 in_29 vref -1.104695e-7
Gw1_30_91 0 sum_h_91 in_30 vref -1.041001e-7
Gw1_31_91 0 sum_h_91 in_31 vref 2.019672e-8
Gw1_32_91 0 sum_h_91 in_32 vref -4.147814e-8
Gw1_33_91 0 sum_h_91 in_33 vref 1.685445e-8
Gw1_34_91 0 sum_h_91 in_34 vref -7.320784e-8
Gw1_35_91 0 sum_h_91 in_35 vref -1.678070e-8
Gw1_36_91 0 sum_h_91 in_36 vref -5.067054e-8
Gw1_37_91 0 sum_h_91 in_37 vref -9.118310e-8
Gw1_38_91 0 sum_h_91 in_38 vref -2.104905e-8
Gw1_39_91 0 sum_h_91 in_39 vref -1.038877e-7
Gw1_40_91 0 sum_h_91 in_40 vref -7.144721e-9
Gw1_41_91 0 sum_h_91 in_41 vref -7.225120e-8
Gw1_42_91 0 sum_h_91 in_42 vref 7.032882e-8
Gw1_43_91 0 sum_h_91 in_43 vref -5.230343e-8
Gw1_44_91 0 sum_h_91 in_44 vref 1.025341e-7
Gw1_45_91 0 sum_h_91 in_45 vref -1.158861e-7
Gw1_46_91 0 sum_h_91 in_46 vref -4.582044e-8
Gw1_47_91 0 sum_h_91 in_47 vref -1.223313e-7
Gw1_48_91 0 sum_h_91 in_48 vref 8.810030e-8
Gw1_0_92 0 sum_h_92 in_0 vref 7.016488e-8
Gw1_1_92 0 sum_h_92 in_1 vref 9.964771e-8
Gw1_2_92 0 sum_h_92 in_2 vref -1.424403e-9
Gw1_3_92 0 sum_h_92 in_3 vref -1.785034e-8
Gw1_4_92 0 sum_h_92 in_4 vref -1.067372e-7
Gw1_5_92 0 sum_h_92 in_5 vref 1.850065e-8
Gw1_6_92 0 sum_h_92 in_6 vref 7.949181e-9
Gw1_7_92 0 sum_h_92 in_7 vref -4.484340e-8
Gw1_8_92 0 sum_h_92 in_8 vref 3.110070e-8
Gw1_9_92 0 sum_h_92 in_9 vref -2.068951e-8
Gw1_10_92 0 sum_h_92 in_10 vref -1.830430e-8
Gw1_11_92 0 sum_h_92 in_11 vref 8.895395e-8
Gw1_12_92 0 sum_h_92 in_12 vref 1.165560e-7
Gw1_13_92 0 sum_h_92 in_13 vref 1.082003e-7
Gw1_14_92 0 sum_h_92 in_14 vref -3.289663e-8
Gw1_15_92 0 sum_h_92 in_15 vref 6.119486e-9
Gw1_16_92 0 sum_h_92 in_16 vref 5.724385e-8
Gw1_17_92 0 sum_h_92 in_17 vref 2.829419e-9
Gw1_18_92 0 sum_h_92 in_18 vref -9.483003e-9
Gw1_19_92 0 sum_h_92 in_19 vref -1.441243e-7
Gw1_20_92 0 sum_h_92 in_20 vref -1.136953e-7
Gw1_21_92 0 sum_h_92 in_21 vref 9.094597e-8
Gw1_22_92 0 sum_h_92 in_22 vref -6.640470e-8
Gw1_23_92 0 sum_h_92 in_23 vref -1.580719e-7
Gw1_24_92 0 sum_h_92 in_24 vref -8.804310e-8
Gw1_25_92 0 sum_h_92 in_25 vref -1.078514e-7
Gw1_26_92 0 sum_h_92 in_26 vref -1.380210e-7
Gw1_27_92 0 sum_h_92 in_27 vref 7.665506e-8
Gw1_28_92 0 sum_h_92 in_28 vref -1.064754e-7
Gw1_29_92 0 sum_h_92 in_29 vref -1.337979e-8
Gw1_30_92 0 sum_h_92 in_30 vref 2.273567e-7
Gw1_31_92 0 sum_h_92 in_31 vref 1.202271e-7
Gw1_32_92 0 sum_h_92 in_32 vref 8.676741e-8
Gw1_33_92 0 sum_h_92 in_33 vref -1.279098e-7
Gw1_34_92 0 sum_h_92 in_34 vref -4.818350e-8
Gw1_35_92 0 sum_h_92 in_35 vref -1.258246e-7
Gw1_36_92 0 sum_h_92 in_36 vref -1.060832e-7
Gw1_37_92 0 sum_h_92 in_37 vref -2.363406e-7
Gw1_38_92 0 sum_h_92 in_38 vref -3.219325e-10
Gw1_39_92 0 sum_h_92 in_39 vref 6.306648e-8
Gw1_40_92 0 sum_h_92 in_40 vref -1.897933e-7
Gw1_41_92 0 sum_h_92 in_41 vref 1.450592e-7
Gw1_42_92 0 sum_h_92 in_42 vref 1.272117e-8
Gw1_43_92 0 sum_h_92 in_43 vref -7.833460e-8
Gw1_44_92 0 sum_h_92 in_44 vref 1.261433e-7
Gw1_45_92 0 sum_h_92 in_45 vref 2.146475e-7
Gw1_46_92 0 sum_h_92 in_46 vref 1.247036e-7
Gw1_47_92 0 sum_h_92 in_47 vref -3.739155e-8
Gw1_48_92 0 sum_h_92 in_48 vref 6.954929e-8
Gw1_0_93 0 sum_h_93 in_0 vref 1.729273e-8
Gw1_1_93 0 sum_h_93 in_1 vref -2.998400e-8
Gw1_2_93 0 sum_h_93 in_2 vref -3.055192e-10
Gw1_3_93 0 sum_h_93 in_3 vref -3.693424e-8
Gw1_4_93 0 sum_h_93 in_4 vref -6.404272e-8
Gw1_5_93 0 sum_h_93 in_5 vref -9.789590e-8
Gw1_6_93 0 sum_h_93 in_6 vref 2.068461e-9
Gw1_7_93 0 sum_h_93 in_7 vref 1.386366e-8
Gw1_8_93 0 sum_h_93 in_8 vref -1.727519e-7
Gw1_9_93 0 sum_h_93 in_9 vref 2.310275e-7
Gw1_10_93 0 sum_h_93 in_10 vref 1.802102e-7
Gw1_11_93 0 sum_h_93 in_11 vref -1.286597e-7
Gw1_12_93 0 sum_h_93 in_12 vref -1.071458e-8
Gw1_13_93 0 sum_h_93 in_13 vref -2.081785e-8
Gw1_14_93 0 sum_h_93 in_14 vref 1.167482e-7
Gw1_15_93 0 sum_h_93 in_15 vref 1.283707e-7
Gw1_16_93 0 sum_h_93 in_16 vref 2.105286e-8
Gw1_17_93 0 sum_h_93 in_17 vref -2.465687e-7
Gw1_18_93 0 sum_h_93 in_18 vref 3.637178e-8
Gw1_19_93 0 sum_h_93 in_19 vref -1.224473e-8
Gw1_20_93 0 sum_h_93 in_20 vref 2.192189e-8
Gw1_21_93 0 sum_h_93 in_21 vref 1.171770e-8
Gw1_22_93 0 sum_h_93 in_22 vref -8.251241e-8
Gw1_23_93 0 sum_h_93 in_23 vref 7.535294e-9
Gw1_24_93 0 sum_h_93 in_24 vref -2.844609e-9
Gw1_25_93 0 sum_h_93 in_25 vref -3.386910e-8
Gw1_26_93 0 sum_h_93 in_26 vref -5.436820e-8
Gw1_27_93 0 sum_h_93 in_27 vref -4.348033e-8
Gw1_28_93 0 sum_h_93 in_28 vref -1.120601e-8
Gw1_29_93 0 sum_h_93 in_29 vref -1.615340e-7
Gw1_30_93 0 sum_h_93 in_30 vref -1.002692e-7
Gw1_31_93 0 sum_h_93 in_31 vref 1.005596e-7
Gw1_32_93 0 sum_h_93 in_32 vref -5.214212e-8
Gw1_33_93 0 sum_h_93 in_33 vref 5.577623e-8
Gw1_34_93 0 sum_h_93 in_34 vref 2.965174e-8
Gw1_35_93 0 sum_h_93 in_35 vref -3.740599e-8
Gw1_36_93 0 sum_h_93 in_36 vref -2.551180e-8
Gw1_37_93 0 sum_h_93 in_37 vref -5.722281e-8
Gw1_38_93 0 sum_h_93 in_38 vref 9.235907e-8
Gw1_39_93 0 sum_h_93 in_39 vref 2.321253e-7
Gw1_40_93 0 sum_h_93 in_40 vref 1.461553e-7
Gw1_41_93 0 sum_h_93 in_41 vref -4.035609e-8
Gw1_42_93 0 sum_h_93 in_42 vref 3.659642e-8
Gw1_43_93 0 sum_h_93 in_43 vref 9.311739e-8
Gw1_44_93 0 sum_h_93 in_44 vref 1.739275e-7
Gw1_45_93 0 sum_h_93 in_45 vref 5.382439e-8
Gw1_46_93 0 sum_h_93 in_46 vref 6.654885e-8
Gw1_47_93 0 sum_h_93 in_47 vref 1.739109e-7
Gw1_48_93 0 sum_h_93 in_48 vref -1.471276e-8
Gw1_0_94 0 sum_h_94 in_0 vref 1.118701e-7
Gw1_1_94 0 sum_h_94 in_1 vref -6.973870e-8
Gw1_2_94 0 sum_h_94 in_2 vref 5.046956e-9
Gw1_3_94 0 sum_h_94 in_3 vref -4.819458e-8
Gw1_4_94 0 sum_h_94 in_4 vref 3.945912e-8
Gw1_5_94 0 sum_h_94 in_5 vref -2.082443e-9
Gw1_6_94 0 sum_h_94 in_6 vref -6.256411e-8
Gw1_7_94 0 sum_h_94 in_7 vref 1.289264e-7
Gw1_8_94 0 sum_h_94 in_8 vref 2.176999e-9
Gw1_9_94 0 sum_h_94 in_9 vref 1.696424e-7
Gw1_10_94 0 sum_h_94 in_10 vref -1.133687e-7
Gw1_11_94 0 sum_h_94 in_11 vref -7.262756e-8
Gw1_12_94 0 sum_h_94 in_12 vref -1.568147e-8
Gw1_13_94 0 sum_h_94 in_13 vref 1.539073e-7
Gw1_14_94 0 sum_h_94 in_14 vref -6.981320e-8
Gw1_15_94 0 sum_h_94 in_15 vref 6.484102e-8
Gw1_16_94 0 sum_h_94 in_16 vref -1.882183e-8
Gw1_17_94 0 sum_h_94 in_17 vref 8.500146e-8
Gw1_18_94 0 sum_h_94 in_18 vref -6.690549e-8
Gw1_19_94 0 sum_h_94 in_19 vref -2.045793e-7
Gw1_20_94 0 sum_h_94 in_20 vref 1.046837e-7
Gw1_21_94 0 sum_h_94 in_21 vref -9.431493e-8
Gw1_22_94 0 sum_h_94 in_22 vref 4.810239e-8
Gw1_23_94 0 sum_h_94 in_23 vref -2.987195e-8
Gw1_24_94 0 sum_h_94 in_24 vref -1.184674e-7
Gw1_25_94 0 sum_h_94 in_25 vref -8.321007e-8
Gw1_26_94 0 sum_h_94 in_26 vref 8.838284e-8
Gw1_27_94 0 sum_h_94 in_27 vref 2.095421e-7
Gw1_28_94 0 sum_h_94 in_28 vref -3.687287e-8
Gw1_29_94 0 sum_h_94 in_29 vref -1.391577e-7
Gw1_30_94 0 sum_h_94 in_30 vref -1.663062e-7
Gw1_31_94 0 sum_h_94 in_31 vref 1.439724e-7
Gw1_32_94 0 sum_h_94 in_32 vref -8.932900e-8
Gw1_33_94 0 sum_h_94 in_33 vref -1.028073e-7
Gw1_34_94 0 sum_h_94 in_34 vref 1.418901e-7
Gw1_35_94 0 sum_h_94 in_35 vref 1.506616e-7
Gw1_36_94 0 sum_h_94 in_36 vref -6.058012e-8
Gw1_37_94 0 sum_h_94 in_37 vref -9.246328e-8
Gw1_38_94 0 sum_h_94 in_38 vref 1.903305e-7
Gw1_39_94 0 sum_h_94 in_39 vref -2.504363e-8
Gw1_40_94 0 sum_h_94 in_40 vref 4.541092e-8
Gw1_41_94 0 sum_h_94 in_41 vref 6.682302e-8
Gw1_42_94 0 sum_h_94 in_42 vref -5.826708e-8
Gw1_43_94 0 sum_h_94 in_43 vref -1.805429e-8
Gw1_44_94 0 sum_h_94 in_44 vref -6.204947e-8
Gw1_45_94 0 sum_h_94 in_45 vref -9.167860e-8
Gw1_46_94 0 sum_h_94 in_46 vref 1.843451e-7
Gw1_47_94 0 sum_h_94 in_47 vref -1.047155e-7
Gw1_48_94 0 sum_h_94 in_48 vref -6.176921e-8
Gw1_0_95 0 sum_h_95 in_0 vref 3.557133e-8
Gw1_1_95 0 sum_h_95 in_1 vref 1.381220e-7
Gw1_2_95 0 sum_h_95 in_2 vref 1.134078e-7
Gw1_3_95 0 sum_h_95 in_3 vref 2.273493e-8
Gw1_4_95 0 sum_h_95 in_4 vref -4.257624e-8
Gw1_5_95 0 sum_h_95 in_5 vref 1.644760e-7
Gw1_6_95 0 sum_h_95 in_6 vref 5.615253e-8
Gw1_7_95 0 sum_h_95 in_7 vref 1.090984e-7
Gw1_8_95 0 sum_h_95 in_8 vref 1.235681e-8
Gw1_9_95 0 sum_h_95 in_9 vref -1.107731e-7
Gw1_10_95 0 sum_h_95 in_10 vref 7.530650e-8
Gw1_11_95 0 sum_h_95 in_11 vref -8.956641e-8
Gw1_12_95 0 sum_h_95 in_12 vref -7.485992e-9
Gw1_13_95 0 sum_h_95 in_13 vref -4.175426e-8
Gw1_14_95 0 sum_h_95 in_14 vref 1.369516e-7
Gw1_15_95 0 sum_h_95 in_15 vref 1.376597e-7
Gw1_16_95 0 sum_h_95 in_16 vref -1.270663e-7
Gw1_17_95 0 sum_h_95 in_17 vref 4.786487e-8
Gw1_18_95 0 sum_h_95 in_18 vref -5.601942e-9
Gw1_19_95 0 sum_h_95 in_19 vref -3.853007e-8
Gw1_20_95 0 sum_h_95 in_20 vref 5.720087e-8
Gw1_21_95 0 sum_h_95 in_21 vref 1.185398e-7
Gw1_22_95 0 sum_h_95 in_22 vref -7.936437e-8
Gw1_23_95 0 sum_h_95 in_23 vref 7.218283e-8
Gw1_24_95 0 sum_h_95 in_24 vref -4.764362e-8
Gw1_25_95 0 sum_h_95 in_25 vref -7.502493e-8
Gw1_26_95 0 sum_h_95 in_26 vref -1.243338e-7
Gw1_27_95 0 sum_h_95 in_27 vref 1.219902e-7
Gw1_28_95 0 sum_h_95 in_28 vref 8.284403e-8
Gw1_29_95 0 sum_h_95 in_29 vref -2.516050e-9
Gw1_30_95 0 sum_h_95 in_30 vref -5.560551e-8
Gw1_31_95 0 sum_h_95 in_31 vref -1.050592e-7
Gw1_32_95 0 sum_h_95 in_32 vref -1.665113e-8
Gw1_33_95 0 sum_h_95 in_33 vref 4.098061e-8
Gw1_34_95 0 sum_h_95 in_34 vref -1.059030e-7
Gw1_35_95 0 sum_h_95 in_35 vref 1.299070e-7
Gw1_36_95 0 sum_h_95 in_36 vref 9.974022e-8
Gw1_37_95 0 sum_h_95 in_37 vref -6.696376e-9
Gw1_38_95 0 sum_h_95 in_38 vref 9.297809e-8
Gw1_39_95 0 sum_h_95 in_39 vref -8.771568e-8
Gw1_40_95 0 sum_h_95 in_40 vref 1.437375e-7
Gw1_41_95 0 sum_h_95 in_41 vref -1.038466e-7
Gw1_42_95 0 sum_h_95 in_42 vref 1.243084e-7
Gw1_43_95 0 sum_h_95 in_43 vref 1.623516e-7
Gw1_44_95 0 sum_h_95 in_44 vref -1.054032e-7
Gw1_45_95 0 sum_h_95 in_45 vref 9.883435e-8
Gw1_46_95 0 sum_h_95 in_46 vref -1.039435e-7
Gw1_47_95 0 sum_h_95 in_47 vref 9.685169e-8
Gw1_48_95 0 sum_h_95 in_48 vref -7.580772e-8
Gw1_0_96 0 sum_h_96 in_0 vref -1.498639e-7
Gw1_1_96 0 sum_h_96 in_1 vref -7.144079e-8
Gw1_2_96 0 sum_h_96 in_2 vref -1.273058e-7
Gw1_3_96 0 sum_h_96 in_3 vref -1.577767e-7
Gw1_4_96 0 sum_h_96 in_4 vref -5.485025e-8
Gw1_5_96 0 sum_h_96 in_5 vref -1.489466e-7
Gw1_6_96 0 sum_h_96 in_6 vref -1.616266e-7
Gw1_7_96 0 sum_h_96 in_7 vref -4.962045e-10
Gw1_8_96 0 sum_h_96 in_8 vref 4.379823e-8
Gw1_9_96 0 sum_h_96 in_9 vref 2.304873e-7
Gw1_10_96 0 sum_h_96 in_10 vref 1.227444e-7
Gw1_11_96 0 sum_h_96 in_11 vref 1.155770e-7
Gw1_12_96 0 sum_h_96 in_12 vref 4.299486e-8
Gw1_13_96 0 sum_h_96 in_13 vref 1.338834e-7
Gw1_14_96 0 sum_h_96 in_14 vref -1.466397e-7
Gw1_15_96 0 sum_h_96 in_15 vref 7.126398e-8
Gw1_16_96 0 sum_h_96 in_16 vref 2.279515e-8
Gw1_17_96 0 sum_h_96 in_17 vref -7.749452e-8
Gw1_18_96 0 sum_h_96 in_18 vref 3.409647e-8
Gw1_19_96 0 sum_h_96 in_19 vref 3.241729e-8
Gw1_20_96 0 sum_h_96 in_20 vref -8.608779e-8
Gw1_21_96 0 sum_h_96 in_21 vref -1.658880e-7
Gw1_22_96 0 sum_h_96 in_22 vref -2.530609e-7
Gw1_23_96 0 sum_h_96 in_23 vref -3.372625e-8
Gw1_24_96 0 sum_h_96 in_24 vref -6.464999e-8
Gw1_25_96 0 sum_h_96 in_25 vref 8.592987e-8
Gw1_26_96 0 sum_h_96 in_26 vref -7.103128e-8
Gw1_27_96 0 sum_h_96 in_27 vref -4.063083e-8
Gw1_28_96 0 sum_h_96 in_28 vref 3.256461e-8
Gw1_29_96 0 sum_h_96 in_29 vref 8.390224e-8
Gw1_30_96 0 sum_h_96 in_30 vref -2.148916e-7
Gw1_31_96 0 sum_h_96 in_31 vref -1.594567e-7
Gw1_32_96 0 sum_h_96 in_32 vref -1.365947e-8
Gw1_33_96 0 sum_h_96 in_33 vref -1.122669e-7
Gw1_34_96 0 sum_h_96 in_34 vref -2.394500e-8
Gw1_35_96 0 sum_h_96 in_35 vref -1.168401e-7
Gw1_36_96 0 sum_h_96 in_36 vref 1.807339e-7
Gw1_37_96 0 sum_h_96 in_37 vref 7.796120e-8
Gw1_38_96 0 sum_h_96 in_38 vref 1.439859e-7
Gw1_39_96 0 sum_h_96 in_39 vref -8.108932e-9
Gw1_40_96 0 sum_h_96 in_40 vref -4.545475e-8
Gw1_41_96 0 sum_h_96 in_41 vref 3.973544e-8
Gw1_42_96 0 sum_h_96 in_42 vref -2.064921e-9
Gw1_43_96 0 sum_h_96 in_43 vref 1.076876e-9
Gw1_44_96 0 sum_h_96 in_44 vref 6.794481e-8
Gw1_45_96 0 sum_h_96 in_45 vref 1.192884e-7
Gw1_46_96 0 sum_h_96 in_46 vref -1.013836e-7
Gw1_47_96 0 sum_h_96 in_47 vref -1.755362e-7
Gw1_48_96 0 sum_h_96 in_48 vref -6.334989e-8
Gw1_0_97 0 sum_h_97 in_0 vref 5.641222e-8
Gw1_1_97 0 sum_h_97 in_1 vref -8.770073e-8
Gw1_2_97 0 sum_h_97 in_2 vref 9.717747e-8
Gw1_3_97 0 sum_h_97 in_3 vref 1.198397e-7
Gw1_4_97 0 sum_h_97 in_4 vref 1.677847e-8
Gw1_5_97 0 sum_h_97 in_5 vref -8.215046e-8
Gw1_6_97 0 sum_h_97 in_6 vref -3.572458e-8
Gw1_7_97 0 sum_h_97 in_7 vref 6.691969e-8
Gw1_8_97 0 sum_h_97 in_8 vref 3.711741e-8
Gw1_9_97 0 sum_h_97 in_9 vref 6.424023e-8
Gw1_10_97 0 sum_h_97 in_10 vref 1.428150e-7
Gw1_11_97 0 sum_h_97 in_11 vref 1.204191e-8
Gw1_12_97 0 sum_h_97 in_12 vref 7.976074e-8
Gw1_13_97 0 sum_h_97 in_13 vref 1.381566e-7
Gw1_14_97 0 sum_h_97 in_14 vref -7.206587e-8
Gw1_15_97 0 sum_h_97 in_15 vref -4.175797e-8
Gw1_16_97 0 sum_h_97 in_16 vref 1.066086e-7
Gw1_17_97 0 sum_h_97 in_17 vref 5.956822e-8
Gw1_18_97 0 sum_h_97 in_18 vref -2.389505e-8
Gw1_19_97 0 sum_h_97 in_19 vref 7.837498e-8
Gw1_20_97 0 sum_h_97 in_20 vref 4.314688e-8
Gw1_21_97 0 sum_h_97 in_21 vref -6.843315e-8
Gw1_22_97 0 sum_h_97 in_22 vref -1.520941e-8
Gw1_23_97 0 sum_h_97 in_23 vref -4.840270e-8
Gw1_24_97 0 sum_h_97 in_24 vref 6.830640e-8
Gw1_25_97 0 sum_h_97 in_25 vref -1.617669e-7
Gw1_26_97 0 sum_h_97 in_26 vref 1.547974e-7
Gw1_27_97 0 sum_h_97 in_27 vref 6.220061e-8
Gw1_28_97 0 sum_h_97 in_28 vref -6.813767e-8
Gw1_29_97 0 sum_h_97 in_29 vref -1.886241e-7
Gw1_30_97 0 sum_h_97 in_30 vref -2.879252e-7
Gw1_31_97 0 sum_h_97 in_31 vref -8.545837e-8
Gw1_32_97 0 sum_h_97 in_32 vref -3.271355e-9
Gw1_33_97 0 sum_h_97 in_33 vref -2.857825e-8
Gw1_34_97 0 sum_h_97 in_34 vref 2.075461e-8
Gw1_35_97 0 sum_h_97 in_35 vref 1.652094e-8
Gw1_36_97 0 sum_h_97 in_36 vref 5.639111e-8
Gw1_37_97 0 sum_h_97 in_37 vref 1.028105e-7
Gw1_38_97 0 sum_h_97 in_38 vref -4.725105e-9
Gw1_39_97 0 sum_h_97 in_39 vref 7.880913e-8
Gw1_40_97 0 sum_h_97 in_40 vref -1.011277e-7
Gw1_41_97 0 sum_h_97 in_41 vref 3.097360e-9
Gw1_42_97 0 sum_h_97 in_42 vref -1.221806e-7
Gw1_43_97 0 sum_h_97 in_43 vref -7.920573e-9
Gw1_44_97 0 sum_h_97 in_44 vref -3.964655e-8
Gw1_45_97 0 sum_h_97 in_45 vref 1.230493e-7
Gw1_46_97 0 sum_h_97 in_46 vref 2.065559e-8
Gw1_47_97 0 sum_h_97 in_47 vref -1.685755e-8
Gw1_48_97 0 sum_h_97 in_48 vref -3.162665e-8
Gw1_0_98 0 sum_h_98 in_0 vref -6.168020e-8
Gw1_1_98 0 sum_h_98 in_1 vref -6.155109e-8
Gw1_2_98 0 sum_h_98 in_2 vref 7.006064e-8
Gw1_3_98 0 sum_h_98 in_3 vref 7.709637e-8
Gw1_4_98 0 sum_h_98 in_4 vref -9.011480e-8
Gw1_5_98 0 sum_h_98 in_5 vref -3.020542e-9
Gw1_6_98 0 sum_h_98 in_6 vref 4.342301e-8
Gw1_7_98 0 sum_h_98 in_7 vref -4.604826e-8
Gw1_8_98 0 sum_h_98 in_8 vref 1.179989e-8
Gw1_9_98 0 sum_h_98 in_9 vref 4.807234e-8
Gw1_10_98 0 sum_h_98 in_10 vref 2.822429e-8
Gw1_11_98 0 sum_h_98 in_11 vref -2.800245e-7
Gw1_12_98 0 sum_h_98 in_12 vref -1.997636e-7
Gw1_13_98 0 sum_h_98 in_13 vref -7.988007e-8
Gw1_14_98 0 sum_h_98 in_14 vref -8.705076e-8
Gw1_15_98 0 sum_h_98 in_15 vref -6.158033e-8
Gw1_16_98 0 sum_h_98 in_16 vref -4.506329e-8
Gw1_17_98 0 sum_h_98 in_17 vref -4.609224e-8
Gw1_18_98 0 sum_h_98 in_18 vref 1.406708e-7
Gw1_19_98 0 sum_h_98 in_19 vref 2.686161e-8
Gw1_20_98 0 sum_h_98 in_20 vref 1.716891e-7
Gw1_21_98 0 sum_h_98 in_21 vref -1.164222e-7
Gw1_22_98 0 sum_h_98 in_22 vref 8.062771e-8
Gw1_23_98 0 sum_h_98 in_23 vref -4.693765e-9
Gw1_24_98 0 sum_h_98 in_24 vref 1.415583e-8
Gw1_25_98 0 sum_h_98 in_25 vref -8.955431e-8
Gw1_26_98 0 sum_h_98 in_26 vref -6.377633e-8
Gw1_27_98 0 sum_h_98 in_27 vref 1.047088e-7
Gw1_28_98 0 sum_h_98 in_28 vref -5.788860e-8
Gw1_29_98 0 sum_h_98 in_29 vref -7.234172e-8
Gw1_30_98 0 sum_h_98 in_30 vref 5.054039e-8
Gw1_31_98 0 sum_h_98 in_31 vref 1.305868e-7
Gw1_32_98 0 sum_h_98 in_32 vref -1.310659e-7
Gw1_33_98 0 sum_h_98 in_33 vref -1.009726e-7
Gw1_34_98 0 sum_h_98 in_34 vref -1.553007e-7
Gw1_35_98 0 sum_h_98 in_35 vref -2.389793e-8
Gw1_36_98 0 sum_h_98 in_36 vref -1.076437e-7
Gw1_37_98 0 sum_h_98 in_37 vref -2.422933e-7
Gw1_38_98 0 sum_h_98 in_38 vref -1.736970e-7
Gw1_39_98 0 sum_h_98 in_39 vref 1.499678e-8
Gw1_40_98 0 sum_h_98 in_40 vref 1.107157e-7
Gw1_41_98 0 sum_h_98 in_41 vref -8.246383e-8
Gw1_42_98 0 sum_h_98 in_42 vref 1.118367e-7
Gw1_43_98 0 sum_h_98 in_43 vref 8.653296e-8
Gw1_44_98 0 sum_h_98 in_44 vref 3.623219e-8
Gw1_45_98 0 sum_h_98 in_45 vref 1.273725e-7
Gw1_46_98 0 sum_h_98 in_46 vref 2.657581e-7
Gw1_47_98 0 sum_h_98 in_47 vref -4.671257e-8
Gw1_48_98 0 sum_h_98 in_48 vref 4.464191e-8
Gw1_0_99 0 sum_h_99 in_0 vref -1.123413e-7
Gw1_1_99 0 sum_h_99 in_1 vref 3.349737e-8
Gw1_2_99 0 sum_h_99 in_2 vref -8.952339e-9
Gw1_3_99 0 sum_h_99 in_3 vref 8.308449e-8
Gw1_4_99 0 sum_h_99 in_4 vref 9.446750e-8
Gw1_5_99 0 sum_h_99 in_5 vref -5.039696e-8
Gw1_6_99 0 sum_h_99 in_6 vref -6.541968e-8
Gw1_7_99 0 sum_h_99 in_7 vref -3.316649e-8
Gw1_8_99 0 sum_h_99 in_8 vref -2.199768e-7
Gw1_9_99 0 sum_h_99 in_9 vref 8.798862e-8
Gw1_10_99 0 sum_h_99 in_10 vref 2.976346e-8
Gw1_11_99 0 sum_h_99 in_11 vref -3.492643e-8
Gw1_12_99 0 sum_h_99 in_12 vref -4.716043e-9
Gw1_13_99 0 sum_h_99 in_13 vref 1.559155e-8
Gw1_14_99 0 sum_h_99 in_14 vref -6.061133e-8
Gw1_15_99 0 sum_h_99 in_15 vref -1.365633e-8
Gw1_16_99 0 sum_h_99 in_16 vref 2.504209e-7
Gw1_17_99 0 sum_h_99 in_17 vref -1.009514e-7
Gw1_18_99 0 sum_h_99 in_18 vref -8.647199e-8
Gw1_19_99 0 sum_h_99 in_19 vref 1.134441e-7
Gw1_20_99 0 sum_h_99 in_20 vref 3.791448e-8
Gw1_21_99 0 sum_h_99 in_21 vref -4.315784e-8
Gw1_22_99 0 sum_h_99 in_22 vref -3.278006e-8
Gw1_23_99 0 sum_h_99 in_23 vref 1.737664e-7
Gw1_24_99 0 sum_h_99 in_24 vref 5.072816e-8
Gw1_25_99 0 sum_h_99 in_25 vref -4.720604e-8
Gw1_26_99 0 sum_h_99 in_26 vref 1.471231e-8
Gw1_27_99 0 sum_h_99 in_27 vref 5.268951e-8
Gw1_28_99 0 sum_h_99 in_28 vref 6.512647e-8
Gw1_29_99 0 sum_h_99 in_29 vref -8.344298e-8
Gw1_30_99 0 sum_h_99 in_30 vref 1.252200e-7
Gw1_31_99 0 sum_h_99 in_31 vref -6.979164e-8
Gw1_32_99 0 sum_h_99 in_32 vref -1.426562e-7
Gw1_33_99 0 sum_h_99 in_33 vref -1.309240e-7
Gw1_34_99 0 sum_h_99 in_34 vref -1.348236e-7
Gw1_35_99 0 sum_h_99 in_35 vref -4.526487e-9
Gw1_36_99 0 sum_h_99 in_36 vref 1.218762e-8
Gw1_37_99 0 sum_h_99 in_37 vref -7.806189e-9
Gw1_38_99 0 sum_h_99 in_38 vref 1.441775e-8
Gw1_39_99 0 sum_h_99 in_39 vref 3.748642e-8
Gw1_40_99 0 sum_h_99 in_40 vref -5.956231e-8
Gw1_41_99 0 sum_h_99 in_41 vref -1.603697e-8
Gw1_42_99 0 sum_h_99 in_42 vref -1.595458e-7
Gw1_43_99 0 sum_h_99 in_43 vref -1.931609e-8
Gw1_44_99 0 sum_h_99 in_44 vref -1.194519e-7
Gw1_45_99 0 sum_h_99 in_45 vref 1.259199e-7
Gw1_46_99 0 sum_h_99 in_46 vref -1.262155e-9
Gw1_47_99 0 sum_h_99 in_47 vref -1.834081e-8
Gw1_48_99 0 sum_h_99 in_48 vref -1.250886e-7

* Hidden layer bias currents
Ib1_0 0 sum_h_0 DC -1.917462e-8
Ib1_1 0 sum_h_1 DC -3.756705e-8
Ib1_2 0 sum_h_2 DC 8.841334e-8
Ib1_3 0 sum_h_3 DC 1.123554e-7
Ib1_4 0 sum_h_4 DC 1.358698e-9
Ib1_5 0 sum_h_5 DC -1.087452e-7
Ib1_6 0 sum_h_6 DC 1.256323e-7
Ib1_7 0 sum_h_7 DC 1.704128e-8
Ib1_8 0 sum_h_8 DC 8.288312e-8
Ib1_9 0 sum_h_9 DC -5.312741e-8
Ib1_10 0 sum_h_10 DC 1.279017e-7
Ib1_11 0 sum_h_11 DC -1.702095e-8
Ib1_12 0 sum_h_12 DC -8.812482e-8
Ib1_13 0 sum_h_13 DC -7.763643e-8
Ib1_14 0 sum_h_14 DC 3.036905e-8
Ib1_15 0 sum_h_15 DC -5.084771e-8
Ib1_16 0 sum_h_16 DC 9.491509e-8
Ib1_17 0 sum_h_17 DC 3.371140e-9
Ib1_18 0 sum_h_18 DC 5.450874e-8
Ib1_19 0 sum_h_19 DC 1.749699e-8
Ib1_20 0 sum_h_20 DC 3.615393e-9
Ib1_21 0 sum_h_21 DC -5.712565e-8
Ib1_22 0 sum_h_22 DC 3.720925e-8
Ib1_23 0 sum_h_23 DC 8.838402e-8
Ib1_24 0 sum_h_24 DC -2.359744e-8
Ib1_25 0 sum_h_25 DC -7.842784e-8
Ib1_26 0 sum_h_26 DC -9.173102e-8
Ib1_27 0 sum_h_27 DC 6.275174e-8
Ib1_28 0 sum_h_28 DC -4.366221e-8
Ib1_29 0 sum_h_29 DC -1.193275e-7
Ib1_30 0 sum_h_30 DC 9.546184e-8
Ib1_31 0 sum_h_31 DC 1.050374e-8
Ib1_32 0 sum_h_32 DC 7.907681e-8
Ib1_33 0 sum_h_33 DC 1.068320e-7
Ib1_34 0 sum_h_34 DC -1.459545e-8
Ib1_35 0 sum_h_35 DC -9.796683e-8
Ib1_36 0 sum_h_36 DC 4.593797e-8
Ib1_37 0 sum_h_37 DC -1.035624e-7
Ib1_38 0 sum_h_38 DC -1.636239e-8
Ib1_39 0 sum_h_39 DC -1.354750e-7
Ib1_40 0 sum_h_40 DC 7.427279e-8
Ib1_41 0 sum_h_41 DC 5.235867e-8
Ib1_42 0 sum_h_42 DC -3.154122e-8
Ib1_43 0 sum_h_43 DC -5.379591e-8
Ib1_44 0 sum_h_44 DC 1.723502e-8
Ib1_45 0 sum_h_45 DC 4.424185e-8
Ib1_46 0 sum_h_46 DC 9.336865e-9
Ib1_47 0 sum_h_47 DC -1.762891e-8
Ib1_48 0 sum_h_48 DC 4.543594e-8
Ib1_49 0 sum_h_49 DC -1.474173e-7
Ib1_50 0 sum_h_50 DC 1.243302e-7
Ib1_51 0 sum_h_51 DC -9.053366e-8
Ib1_52 0 sum_h_52 DC 1.460419e-8
Ib1_53 0 sum_h_53 DC 4.306663e-8
Ib1_54 0 sum_h_54 DC 4.680976e-8
Ib1_55 0 sum_h_55 DC -3.838804e-8
Ib1_56 0 sum_h_56 DC 1.267993e-7
Ib1_57 0 sum_h_57 DC 7.553363e-8
Ib1_58 0 sum_h_58 DC 1.121917e-7
Ib1_59 0 sum_h_59 DC 1.523400e-7
Ib1_60 0 sum_h_60 DC -9.381633e-9
Ib1_61 0 sum_h_61 DC 3.747857e-8
Ib1_62 0 sum_h_62 DC 6.570756e-8
Ib1_63 0 sum_h_63 DC 1.410086e-7
Ib1_64 0 sum_h_64 DC -9.574018e-8
Ib1_65 0 sum_h_65 DC 2.064685e-8
Ib1_66 0 sum_h_66 DC 1.583713e-7
Ib1_67 0 sum_h_67 DC -9.578435e-8
Ib1_68 0 sum_h_68 DC -8.367250e-8
Ib1_69 0 sum_h_69 DC 4.848126e-8
Ib1_70 0 sum_h_70 DC 1.006210e-7
Ib1_71 0 sum_h_71 DC -9.861139e-8
Ib1_72 0 sum_h_72 DC -5.235130e-8
Ib1_73 0 sum_h_73 DC 3.254492e-8
Ib1_74 0 sum_h_74 DC -1.098405e-7
Ib1_75 0 sum_h_75 DC 1.467504e-7
Ib1_76 0 sum_h_76 DC -1.865113e-8
Ib1_77 0 sum_h_77 DC -1.330690e-7
Ib1_78 0 sum_h_78 DC -3.312468e-8
Ib1_79 0 sum_h_79 DC -6.678913e-8
Ib1_80 0 sum_h_80 DC -7.779393e-8
Ib1_81 0 sum_h_81 DC 1.569385e-7
Ib1_82 0 sum_h_82 DC -2.458334e-8
Ib1_83 0 sum_h_83 DC 6.580505e-8
Ib1_84 0 sum_h_84 DC 1.665856e-8
Ib1_85 0 sum_h_85 DC -1.398566e-7
Ib1_86 0 sum_h_86 DC -1.395532e-7
Ib1_87 0 sum_h_87 DC -6.888023e-8
Ib1_88 0 sum_h_88 DC -5.512094e-8
Ib1_89 0 sum_h_89 DC 7.347664e-8
Ib1_90 0 sum_h_90 DC -7.763045e-8
Ib1_91 0 sum_h_91 DC -8.957775e-8
Ib1_92 0 sum_h_92 DC -9.529598e-8
Ib1_93 0 sum_h_93 DC -9.680496e-9
Ib1_94 0 sum_h_94 DC 8.523903e-8
Ib1_95 0 sum_h_95 DC 4.646037e-9
Ib1_96 0 sum_h_96 DC -5.889122e-8
Ib1_97 0 sum_h_97 DC 1.113362e-7
Ib1_98 0 sum_h_98 DC -8.460775e-8
Ib1_99 0 sum_h_99 DC -1.033822e-7

* ========== Output Layer Neurons ==========
Xo_0 mem_o_0 vref vdd pulse_o_0 ana_o_0 sum_o_0 lif_neuron
Xo_1 mem_o_1 vref vdd pulse_o_1 ana_o_1 sum_o_1 lif_neuron
Xo_2 mem_o_2 vref vdd pulse_o_2 ana_o_2 sum_o_2 lif_neuron
Xo_3 mem_o_3 vref vdd pulse_o_3 ana_o_3 sum_o_3 lif_neuron
Xo_4 mem_o_4 vref vdd pulse_o_4 ana_o_4 sum_o_4 lif_neuron
Xo_5 mem_o_5 vref vdd pulse_o_5 ana_o_5 sum_o_5 lif_neuron
Xo_6 mem_o_6 vref vdd pulse_o_6 ana_o_6 sum_o_6 lif_neuron
Xo_7 mem_o_7 vref vdd pulse_o_7 ana_o_7 sum_o_7 lif_neuron
Xo_8 mem_o_8 vref vdd pulse_o_8 ana_o_8 sum_o_8 lif_neuron
Xo_9 mem_o_9 vref vdd pulse_o_9 ana_o_9 sum_o_9 lif_neuron

* ========== Hidden -> Output Synapses (VCCS) ==========
* Uses stretched pulse output (pulse_h_*) for better charge transfer
Gw2_0_0 0 sum_o_0 pulse_h_0 0 -1.571432e-7
Gw2_1_0 0 sum_o_0 pulse_h_1 0 1.561763e-7
Gw2_2_0 0 sum_o_0 pulse_h_2 0 -5.042954e-8
Gw2_3_0 0 sum_o_0 pulse_h_3 0 9.517968e-8
Gw2_4_0 0 sum_o_0 pulse_h_4 0 -1.561939e-7
Gw2_5_0 0 sum_o_0 pulse_h_5 0 1.497557e-8
Gw2_6_0 0 sum_o_0 pulse_h_6 0 -5.055057e-8
Gw2_7_0 0 sum_o_0 pulse_h_7 0 5.490920e-8
Gw2_8_0 0 sum_o_0 pulse_h_8 0 -2.065016e-7
Gw2_9_0 0 sum_o_0 pulse_h_9 0 1.094377e-8
Gw2_10_0 0 sum_o_0 pulse_h_10 0 -4.025672e-8
Gw2_11_0 0 sum_o_0 pulse_h_11 0 1.395671e-8
Gw2_12_0 0 sum_o_0 pulse_h_12 0 1.846837e-7
Gw2_13_0 0 sum_o_0 pulse_h_13 0 7.207011e-8
Gw2_14_0 0 sum_o_0 pulse_h_14 0 2.414875e-9
Gw2_15_0 0 sum_o_0 pulse_h_15 0 -3.055134e-8
Gw2_16_0 0 sum_o_0 pulse_h_16 0 -8.928276e-8
Gw2_17_0 0 sum_o_0 pulse_h_17 0 -1.034222e-7
Gw2_18_0 0 sum_o_0 pulse_h_18 0 -5.042653e-9
Gw2_19_0 0 sum_o_0 pulse_h_19 0 -1.199332e-7
Gw2_20_0 0 sum_o_0 pulse_h_20 0 -1.254861e-7
Gw2_21_0 0 sum_o_0 pulse_h_21 0 -1.568857e-7
Gw2_22_0 0 sum_o_0 pulse_h_22 0 9.458758e-8
Gw2_23_0 0 sum_o_0 pulse_h_23 0 -1.648090e-8
Gw2_24_0 0 sum_o_0 pulse_h_24 0 4.839460e-8
Gw2_25_0 0 sum_o_0 pulse_h_25 0 1.844470e-7
Gw2_26_0 0 sum_o_0 pulse_h_26 0 -2.221792e-7
Gw2_27_0 0 sum_o_0 pulse_h_27 0 1.202017e-8
Gw2_28_0 0 sum_o_0 pulse_h_28 0 -1.879131e-7
Gw2_29_0 0 sum_o_0 pulse_h_29 0 -3.744480e-8
Gw2_30_0 0 sum_o_0 pulse_h_30 0 -2.302089e-8
Gw2_31_0 0 sum_o_0 pulse_h_31 0 -1.920465e-8
Gw2_32_0 0 sum_o_0 pulse_h_32 0 -3.436690e-8
Gw2_33_0 0 sum_o_0 pulse_h_33 0 4.488220e-8
Gw2_34_0 0 sum_o_0 pulse_h_34 0 6.020286e-8
Gw2_35_0 0 sum_o_0 pulse_h_35 0 -1.309965e-7
Gw2_36_0 0 sum_o_0 pulse_h_36 0 6.497974e-8
Gw2_37_0 0 sum_o_0 pulse_h_37 0 -7.401431e-8
Gw2_38_0 0 sum_o_0 pulse_h_38 0 5.351288e-8
Gw2_39_0 0 sum_o_0 pulse_h_39 0 8.960425e-9
Gw2_40_0 0 sum_o_0 pulse_h_40 0 -1.940381e-7
Gw2_41_0 0 sum_o_0 pulse_h_41 0 2.410884e-8
Gw2_42_0 0 sum_o_0 pulse_h_42 0 5.773041e-8
Gw2_43_0 0 sum_o_0 pulse_h_43 0 4.557169e-8
Gw2_44_0 0 sum_o_0 pulse_h_44 0 -2.594126e-8
Gw2_45_0 0 sum_o_0 pulse_h_45 0 2.425830e-8
Gw2_46_0 0 sum_o_0 pulse_h_46 0 6.966600e-8
Gw2_47_0 0 sum_o_0 pulse_h_47 0 -8.074547e-8
Gw2_48_0 0 sum_o_0 pulse_h_48 0 2.906197e-8
Gw2_49_0 0 sum_o_0 pulse_h_49 0 1.082840e-7
Gw2_50_0 0 sum_o_0 pulse_h_50 0 5.662232e-8
Gw2_51_0 0 sum_o_0 pulse_h_51 0 -8.063949e-9
Gw2_52_0 0 sum_o_0 pulse_h_52 0 1.214879e-7
Gw2_53_0 0 sum_o_0 pulse_h_53 0 -2.169505e-8
Gw2_54_0 0 sum_o_0 pulse_h_54 0 -4.647812e-8
Gw2_55_0 0 sum_o_0 pulse_h_55 0 3.463742e-8
Gw2_56_0 0 sum_o_0 pulse_h_56 0 4.996357e-8
Gw2_57_0 0 sum_o_0 pulse_h_57 0 -6.928241e-8
Gw2_58_0 0 sum_o_0 pulse_h_58 0 3.366862e-8
Gw2_59_0 0 sum_o_0 pulse_h_59 0 1.463340e-7
Gw2_60_0 0 sum_o_0 pulse_h_60 0 1.466297e-7
Gw2_61_0 0 sum_o_0 pulse_h_61 0 5.437878e-8
Gw2_62_0 0 sum_o_0 pulse_h_62 0 -1.239833e-7
Gw2_63_0 0 sum_o_0 pulse_h_63 0 5.629305e-8
Gw2_64_0 0 sum_o_0 pulse_h_64 0 6.249569e-9
Gw2_65_0 0 sum_o_0 pulse_h_65 0 8.871671e-8
Gw2_66_0 0 sum_o_0 pulse_h_66 0 -4.287562e-8
Gw2_67_0 0 sum_o_0 pulse_h_67 0 5.685115e-8
Gw2_68_0 0 sum_o_0 pulse_h_68 0 1.740281e-9
Gw2_69_0 0 sum_o_0 pulse_h_69 0 6.066896e-8
Gw2_70_0 0 sum_o_0 pulse_h_70 0 -2.826256e-7
Gw2_71_0 0 sum_o_0 pulse_h_71 0 -8.463076e-9
Gw2_72_0 0 sum_o_0 pulse_h_72 0 -2.297270e-8
Gw2_73_0 0 sum_o_0 pulse_h_73 0 9.463250e-8
Gw2_74_0 0 sum_o_0 pulse_h_74 0 -4.948837e-8
Gw2_75_0 0 sum_o_0 pulse_h_75 0 -7.563946e-9
Gw2_76_0 0 sum_o_0 pulse_h_76 0 6.785016e-8
Gw2_77_0 0 sum_o_0 pulse_h_77 0 -6.669059e-8
Gw2_78_0 0 sum_o_0 pulse_h_78 0 2.122974e-8
Gw2_79_0 0 sum_o_0 pulse_h_79 0 8.462002e-8
Gw2_80_0 0 sum_o_0 pulse_h_80 0 3.238294e-8
Gw2_81_0 0 sum_o_0 pulse_h_81 0 -2.497418e-8
Gw2_82_0 0 sum_o_0 pulse_h_82 0 -2.716284e-8
Gw2_83_0 0 sum_o_0 pulse_h_83 0 -5.795350e-8
Gw2_84_0 0 sum_o_0 pulse_h_84 0 -4.002792e-8
Gw2_85_0 0 sum_o_0 pulse_h_85 0 3.325120e-8
Gw2_86_0 0 sum_o_0 pulse_h_86 0 -4.077670e-8
Gw2_87_0 0 sum_o_0 pulse_h_87 0 -3.427285e-8
Gw2_88_0 0 sum_o_0 pulse_h_88 0 1.063149e-7
Gw2_89_0 0 sum_o_0 pulse_h_89 0 -5.039890e-8
Gw2_90_0 0 sum_o_0 pulse_h_90 0 -2.350408e-7
Gw2_91_0 0 sum_o_0 pulse_h_91 0 -1.441668e-7
Gw2_92_0 0 sum_o_0 pulse_h_92 0 -3.218686e-7
Gw2_93_0 0 sum_o_0 pulse_h_93 0 1.608210e-8
Gw2_94_0 0 sum_o_0 pulse_h_94 0 1.818618e-8
Gw2_95_0 0 sum_o_0 pulse_h_95 0 -8.097164e-8
Gw2_96_0 0 sum_o_0 pulse_h_96 0 9.638703e-8
Gw2_97_0 0 sum_o_0 pulse_h_97 0 5.450993e-8
Gw2_98_0 0 sum_o_0 pulse_h_98 0 -3.922530e-8
Gw2_99_0 0 sum_o_0 pulse_h_99 0 -3.293943e-8
Gw2_0_1 0 sum_o_1 pulse_h_0 0 5.678634e-8
Gw2_1_1 0 sum_o_1 pulse_h_1 0 2.296180e-8
Gw2_2_1 0 sum_o_1 pulse_h_2 0 1.128065e-7
Gw2_3_1 0 sum_o_1 pulse_h_3 0 -5.897357e-8
Gw2_4_1 0 sum_o_1 pulse_h_4 0 -9.398466e-8
Gw2_5_1 0 sum_o_1 pulse_h_5 0 -7.095114e-8
Gw2_6_1 0 sum_o_1 pulse_h_6 0 -5.860996e-8
Gw2_7_1 0 sum_o_1 pulse_h_7 0 3.608596e-8
Gw2_8_1 0 sum_o_1 pulse_h_8 0 7.578712e-8
Gw2_9_1 0 sum_o_1 pulse_h_9 0 1.084159e-8
Gw2_10_1 0 sum_o_1 pulse_h_10 0 1.354536e-7
Gw2_11_1 0 sum_o_1 pulse_h_11 0 -1.068713e-7
Gw2_12_1 0 sum_o_1 pulse_h_12 0 1.252585e-7
Gw2_13_1 0 sum_o_1 pulse_h_13 0 -4.549626e-8
Gw2_14_1 0 sum_o_1 pulse_h_14 0 -4.280465e-8
Gw2_15_1 0 sum_o_1 pulse_h_15 0 8.431056e-8
Gw2_16_1 0 sum_o_1 pulse_h_16 0 6.560026e-8
Gw2_17_1 0 sum_o_1 pulse_h_17 0 1.646449e-8
Gw2_18_1 0 sum_o_1 pulse_h_18 0 -2.734836e-8
Gw2_19_1 0 sum_o_1 pulse_h_19 0 -1.326587e-8
Gw2_20_1 0 sum_o_1 pulse_h_20 0 5.837299e-8
Gw2_21_1 0 sum_o_1 pulse_h_21 0 1.730363e-7
Gw2_22_1 0 sum_o_1 pulse_h_22 0 -2.118650e-7
Gw2_23_1 0 sum_o_1 pulse_h_23 0 1.692067e-8
Gw2_24_1 0 sum_o_1 pulse_h_24 0 -4.031835e-8
Gw2_25_1 0 sum_o_1 pulse_h_25 0 4.937443e-8
Gw2_26_1 0 sum_o_1 pulse_h_26 0 8.868229e-8
Gw2_27_1 0 sum_o_1 pulse_h_27 0 1.996769e-8
Gw2_28_1 0 sum_o_1 pulse_h_28 0 1.144447e-7
Gw2_29_1 0 sum_o_1 pulse_h_29 0 -2.126808e-8
Gw2_30_1 0 sum_o_1 pulse_h_30 0 -1.014454e-7
Gw2_31_1 0 sum_o_1 pulse_h_31 0 -1.629304e-8
Gw2_32_1 0 sum_o_1 pulse_h_32 0 -5.376332e-8
Gw2_33_1 0 sum_o_1 pulse_h_33 0 -3.033610e-8
Gw2_34_1 0 sum_o_1 pulse_h_34 0 8.718383e-8
Gw2_35_1 0 sum_o_1 pulse_h_35 0 7.141688e-8
Gw2_36_1 0 sum_o_1 pulse_h_36 0 5.096819e-8
Gw2_37_1 0 sum_o_1 pulse_h_37 0 1.224892e-7
Gw2_38_1 0 sum_o_1 pulse_h_38 0 -3.561831e-8
Gw2_39_1 0 sum_o_1 pulse_h_39 0 1.082925e-7
Gw2_40_1 0 sum_o_1 pulse_h_40 0 9.203950e-8
Gw2_41_1 0 sum_o_1 pulse_h_41 0 5.669164e-8
Gw2_42_1 0 sum_o_1 pulse_h_42 0 -7.533993e-8
Gw2_43_1 0 sum_o_1 pulse_h_43 0 6.802588e-8
Gw2_44_1 0 sum_o_1 pulse_h_44 0 1.622745e-8
Gw2_45_1 0 sum_o_1 pulse_h_45 0 1.401119e-7
Gw2_46_1 0 sum_o_1 pulse_h_46 0 -2.072964e-7
Gw2_47_1 0 sum_o_1 pulse_h_47 0 1.499754e-7
Gw2_48_1 0 sum_o_1 pulse_h_48 0 4.154496e-8
Gw2_49_1 0 sum_o_1 pulse_h_49 0 -5.096010e-8
Gw2_50_1 0 sum_o_1 pulse_h_50 0 3.760718e-8
Gw2_51_1 0 sum_o_1 pulse_h_51 0 -2.142986e-7
Gw2_52_1 0 sum_o_1 pulse_h_52 0 5.611944e-8
Gw2_53_1 0 sum_o_1 pulse_h_53 0 -3.791171e-8
Gw2_54_1 0 sum_o_1 pulse_h_54 0 -1.105375e-7
Gw2_55_1 0 sum_o_1 pulse_h_55 0 -9.156551e-9
Gw2_56_1 0 sum_o_1 pulse_h_56 0 -5.478664e-8
Gw2_57_1 0 sum_o_1 pulse_h_57 0 -7.288797e-8
Gw2_58_1 0 sum_o_1 pulse_h_58 0 1.414879e-9
Gw2_59_1 0 sum_o_1 pulse_h_59 0 -1.003141e-7
Gw2_60_1 0 sum_o_1 pulse_h_60 0 1.011154e-8
Gw2_61_1 0 sum_o_1 pulse_h_61 0 -6.525430e-8
Gw2_62_1 0 sum_o_1 pulse_h_62 0 1.280571e-7
Gw2_63_1 0 sum_o_1 pulse_h_63 0 -1.889844e-8
Gw2_64_1 0 sum_o_1 pulse_h_64 0 2.379172e-8
Gw2_65_1 0 sum_o_1 pulse_h_65 0 4.113213e-8
Gw2_66_1 0 sum_o_1 pulse_h_66 0 -7.993091e-8
Gw2_67_1 0 sum_o_1 pulse_h_67 0 -1.078769e-8
Gw2_68_1 0 sum_o_1 pulse_h_68 0 7.070833e-8
Gw2_69_1 0 sum_o_1 pulse_h_69 0 1.114173e-7
Gw2_70_1 0 sum_o_1 pulse_h_70 0 1.404059e-7
Gw2_71_1 0 sum_o_1 pulse_h_71 0 -2.398976e-7
Gw2_72_1 0 sum_o_1 pulse_h_72 0 2.716186e-7
Gw2_73_1 0 sum_o_1 pulse_h_73 0 -9.360814e-8
Gw2_74_1 0 sum_o_1 pulse_h_74 0 -3.117388e-7
Gw2_75_1 0 sum_o_1 pulse_h_75 0 -4.849808e-8
Gw2_76_1 0 sum_o_1 pulse_h_76 0 5.534173e-8
Gw2_77_1 0 sum_o_1 pulse_h_77 0 3.295665e-8
Gw2_78_1 0 sum_o_1 pulse_h_78 0 1.255233e-7
Gw2_79_1 0 sum_o_1 pulse_h_79 0 -1.139285e-7
Gw2_80_1 0 sum_o_1 pulse_h_80 0 2.217649e-8
Gw2_81_1 0 sum_o_1 pulse_h_81 0 4.037427e-8
Gw2_82_1 0 sum_o_1 pulse_h_82 0 7.002742e-9
Gw2_83_1 0 sum_o_1 pulse_h_83 0 8.338006e-8
Gw2_84_1 0 sum_o_1 pulse_h_84 0 2.290080e-8
Gw2_85_1 0 sum_o_1 pulse_h_85 0 1.247898e-8
Gw2_86_1 0 sum_o_1 pulse_h_86 0 -1.146097e-7
Gw2_87_1 0 sum_o_1 pulse_h_87 0 1.731501e-7
Gw2_88_1 0 sum_o_1 pulse_h_88 0 -4.201400e-8
Gw2_89_1 0 sum_o_1 pulse_h_89 0 1.194534e-7
Gw2_90_1 0 sum_o_1 pulse_h_90 0 -1.000377e-7
Gw2_91_1 0 sum_o_1 pulse_h_91 0 -2.127651e-8
Gw2_92_1 0 sum_o_1 pulse_h_92 0 -1.449850e-7
Gw2_93_1 0 sum_o_1 pulse_h_93 0 -2.195751e-8
Gw2_94_1 0 sum_o_1 pulse_h_94 0 3.141003e-8
Gw2_95_1 0 sum_o_1 pulse_h_95 0 2.005678e-8
Gw2_96_1 0 sum_o_1 pulse_h_96 0 -6.521167e-8
Gw2_97_1 0 sum_o_1 pulse_h_97 0 8.627219e-8
Gw2_98_1 0 sum_o_1 pulse_h_98 0 -7.063053e-8
Gw2_99_1 0 sum_o_1 pulse_h_99 0 -6.376617e-8
Gw2_0_2 0 sum_o_2 pulse_h_0 0 7.940124e-8
Gw2_1_2 0 sum_o_2 pulse_h_1 0 3.195530e-8
Gw2_2_2 0 sum_o_2 pulse_h_2 0 8.661331e-8
Gw2_3_2 0 sum_o_2 pulse_h_3 0 2.874106e-8
Gw2_4_2 0 sum_o_2 pulse_h_4 0 -1.399265e-7
Gw2_5_2 0 sum_o_2 pulse_h_5 0 -3.262441e-8
Gw2_6_2 0 sum_o_2 pulse_h_6 0 -2.783376e-8
Gw2_7_2 0 sum_o_2 pulse_h_7 0 -3.204761e-8
Gw2_8_2 0 sum_o_2 pulse_h_8 0 -7.741220e-8
Gw2_9_2 0 sum_o_2 pulse_h_9 0 1.818883e-7
Gw2_10_2 0 sum_o_2 pulse_h_10 0 -4.901340e-8
Gw2_11_2 0 sum_o_2 pulse_h_11 0 -2.083014e-7
Gw2_12_2 0 sum_o_2 pulse_h_12 0 6.357224e-8
Gw2_13_2 0 sum_o_2 pulse_h_13 0 -1.151243e-9
Gw2_14_2 0 sum_o_2 pulse_h_14 0 9.920640e-8
Gw2_15_2 0 sum_o_2 pulse_h_15 0 1.170735e-7
Gw2_16_2 0 sum_o_2 pulse_h_16 0 -4.401075e-8
Gw2_17_2 0 sum_o_2 pulse_h_17 0 1.228869e-8
Gw2_18_2 0 sum_o_2 pulse_h_18 0 3.348327e-8
Gw2_19_2 0 sum_o_2 pulse_h_19 0 1.532473e-7
Gw2_20_2 0 sum_o_2 pulse_h_20 0 4.738200e-8
Gw2_21_2 0 sum_o_2 pulse_h_21 0 1.145078e-7
Gw2_22_2 0 sum_o_2 pulse_h_22 0 -2.337316e-7
Gw2_23_2 0 sum_o_2 pulse_h_23 0 1.592688e-7
Gw2_24_2 0 sum_o_2 pulse_h_24 0 1.462258e-7
Gw2_25_2 0 sum_o_2 pulse_h_25 0 -1.617619e-7
Gw2_26_2 0 sum_o_2 pulse_h_26 0 1.122416e-7
Gw2_27_2 0 sum_o_2 pulse_h_27 0 -6.074188e-8
Gw2_28_2 0 sum_o_2 pulse_h_28 0 3.408958e-8
Gw2_29_2 0 sum_o_2 pulse_h_29 0 -4.073271e-8
Gw2_30_2 0 sum_o_2 pulse_h_30 0 -9.799196e-8
Gw2_31_2 0 sum_o_2 pulse_h_31 0 6.697851e-8
Gw2_32_2 0 sum_o_2 pulse_h_32 0 1.223675e-8
Gw2_33_2 0 sum_o_2 pulse_h_33 0 5.737512e-8
Gw2_34_2 0 sum_o_2 pulse_h_34 0 4.447587e-8
Gw2_35_2 0 sum_o_2 pulse_h_35 0 -3.769290e-8
Gw2_36_2 0 sum_o_2 pulse_h_36 0 7.384879e-8
Gw2_37_2 0 sum_o_2 pulse_h_37 0 -3.529444e-8
Gw2_38_2 0 sum_o_2 pulse_h_38 0 3.675311e-8
Gw2_39_2 0 sum_o_2 pulse_h_39 0 -1.147166e-7
Gw2_40_2 0 sum_o_2 pulse_h_40 0 1.875347e-8
Gw2_41_2 0 sum_o_2 pulse_h_41 0 3.939432e-8
Gw2_42_2 0 sum_o_2 pulse_h_42 0 1.880077e-7
Gw2_43_2 0 sum_o_2 pulse_h_43 0 -1.022432e-7
Gw2_44_2 0 sum_o_2 pulse_h_44 0 -4.334185e-8
Gw2_45_2 0 sum_o_2 pulse_h_45 0 4.192928e-8
Gw2_46_2 0 sum_o_2 pulse_h_46 0 5.664362e-8
Gw2_47_2 0 sum_o_2 pulse_h_47 0 -4.042089e-8
Gw2_48_2 0 sum_o_2 pulse_h_48 0 -4.016790e-8
Gw2_49_2 0 sum_o_2 pulse_h_49 0 -1.041761e-9
Gw2_50_2 0 sum_o_2 pulse_h_50 0 4.288395e-8
Gw2_51_2 0 sum_o_2 pulse_h_51 0 -8.456369e-9
Gw2_52_2 0 sum_o_2 pulse_h_52 0 3.497535e-8
Gw2_53_2 0 sum_o_2 pulse_h_53 0 -2.823247e-8
Gw2_54_2 0 sum_o_2 pulse_h_54 0 -1.262675e-8
Gw2_55_2 0 sum_o_2 pulse_h_55 0 -1.433255e-7
Gw2_56_2 0 sum_o_2 pulse_h_56 0 -3.728828e-9
Gw2_57_2 0 sum_o_2 pulse_h_57 0 6.491957e-8
Gw2_58_2 0 sum_o_2 pulse_h_58 0 8.039154e-8
Gw2_59_2 0 sum_o_2 pulse_h_59 0 8.041029e-8
Gw2_60_2 0 sum_o_2 pulse_h_60 0 -1.187297e-7
Gw2_61_2 0 sum_o_2 pulse_h_61 0 8.596142e-8
Gw2_62_2 0 sum_o_2 pulse_h_62 0 -2.118637e-7
Gw2_63_2 0 sum_o_2 pulse_h_63 0 1.093029e-8
Gw2_64_2 0 sum_o_2 pulse_h_64 0 6.417420e-9
Gw2_65_2 0 sum_o_2 pulse_h_65 0 5.903984e-9
Gw2_66_2 0 sum_o_2 pulse_h_66 0 1.408490e-9
Gw2_67_2 0 sum_o_2 pulse_h_67 0 3.727701e-8
Gw2_68_2 0 sum_o_2 pulse_h_68 0 1.562685e-8
Gw2_69_2 0 sum_o_2 pulse_h_69 0 6.677439e-8
Gw2_70_2 0 sum_o_2 pulse_h_70 0 -1.247144e-8
Gw2_71_2 0 sum_o_2 pulse_h_71 0 1.360903e-7
Gw2_72_2 0 sum_o_2 pulse_h_72 0 1.370878e-8
Gw2_73_2 0 sum_o_2 pulse_h_73 0 2.033475e-8
Gw2_74_2 0 sum_o_2 pulse_h_74 0 -5.408690e-8
Gw2_75_2 0 sum_o_2 pulse_h_75 0 4.419749e-8
Gw2_76_2 0 sum_o_2 pulse_h_76 0 -2.624265e-8
Gw2_77_2 0 sum_o_2 pulse_h_77 0 -1.269799e-7
Gw2_78_2 0 sum_o_2 pulse_h_78 0 3.605761e-8
Gw2_79_2 0 sum_o_2 pulse_h_79 0 1.973842e-7
Gw2_80_2 0 sum_o_2 pulse_h_80 0 1.437201e-7
Gw2_81_2 0 sum_o_2 pulse_h_81 0 8.602136e-8
Gw2_82_2 0 sum_o_2 pulse_h_82 0 -9.344887e-8
Gw2_83_2 0 sum_o_2 pulse_h_83 0 1.959984e-7
Gw2_84_2 0 sum_o_2 pulse_h_84 0 -8.576588e-8
Gw2_85_2 0 sum_o_2 pulse_h_85 0 -5.756110e-8
Gw2_86_2 0 sum_o_2 pulse_h_86 0 -4.412469e-8
Gw2_87_2 0 sum_o_2 pulse_h_87 0 -1.123312e-7
Gw2_88_2 0 sum_o_2 pulse_h_88 0 5.437945e-8
Gw2_89_2 0 sum_o_2 pulse_h_89 0 -6.570563e-8
Gw2_90_2 0 sum_o_2 pulse_h_90 0 6.156642e-8
Gw2_91_2 0 sum_o_2 pulse_h_91 0 -6.635928e-8
Gw2_92_2 0 sum_o_2 pulse_h_92 0 -1.551915e-7
Gw2_93_2 0 sum_o_2 pulse_h_93 0 5.375444e-9
Gw2_94_2 0 sum_o_2 pulse_h_94 0 1.660846e-7
Gw2_95_2 0 sum_o_2 pulse_h_95 0 -4.246794e-8
Gw2_96_2 0 sum_o_2 pulse_h_96 0 1.655724e-8
Gw2_97_2 0 sum_o_2 pulse_h_97 0 -4.763094e-8
Gw2_98_2 0 sum_o_2 pulse_h_98 0 -3.822085e-8
Gw2_99_2 0 sum_o_2 pulse_h_99 0 -8.520635e-8
Gw2_0_3 0 sum_o_3 pulse_h_0 0 7.047691e-8
Gw2_1_3 0 sum_o_3 pulse_h_1 0 -1.646434e-7
Gw2_2_3 0 sum_o_3 pulse_h_2 0 1.912715e-8
Gw2_3_3 0 sum_o_3 pulse_h_3 0 6.808400e-8
Gw2_4_3 0 sum_o_3 pulse_h_4 0 -1.126835e-7
Gw2_5_3 0 sum_o_3 pulse_h_5 0 2.653935e-8
Gw2_6_3 0 sum_o_3 pulse_h_6 0 2.392510e-8
Gw2_7_3 0 sum_o_3 pulse_h_7 0 -1.351657e-7
Gw2_8_3 0 sum_o_3 pulse_h_8 0 1.424412e-7
Gw2_9_3 0 sum_o_3 pulse_h_9 0 1.191206e-7
Gw2_10_3 0 sum_o_3 pulse_h_10 0 1.161815e-9
Gw2_11_3 0 sum_o_3 pulse_h_11 0 5.770684e-8
Gw2_12_3 0 sum_o_3 pulse_h_12 0 4.512486e-9
Gw2_13_3 0 sum_o_3 pulse_h_13 0 -5.875270e-9
Gw2_14_3 0 sum_o_3 pulse_h_14 0 -7.997982e-8
Gw2_15_3 0 sum_o_3 pulse_h_15 0 -1.504709e-8
Gw2_16_3 0 sum_o_3 pulse_h_16 0 5.190832e-8
Gw2_17_3 0 sum_o_3 pulse_h_17 0 8.422425e-8
Gw2_18_3 0 sum_o_3 pulse_h_18 0 9.391403e-8
Gw2_19_3 0 sum_o_3 pulse_h_19 0 4.561560e-8
Gw2_20_3 0 sum_o_3 pulse_h_20 0 -9.638314e-8
Gw2_21_3 0 sum_o_3 pulse_h_21 0 1.493135e-7
Gw2_22_3 0 sum_o_3 pulse_h_22 0 -3.672318e-8
Gw2_23_3 0 sum_o_3 pulse_h_23 0 -8.132070e-8
Gw2_24_3 0 sum_o_3 pulse_h_24 0 -9.120730e-8
Gw2_25_3 0 sum_o_3 pulse_h_25 0 -8.631059e-8
Gw2_26_3 0 sum_o_3 pulse_h_26 0 -4.911416e-8
Gw2_27_3 0 sum_o_3 pulse_h_27 0 -7.176632e-8
Gw2_28_3 0 sum_o_3 pulse_h_28 0 6.926395e-8
Gw2_29_3 0 sum_o_3 pulse_h_29 0 -1.854658e-8
Gw2_30_3 0 sum_o_3 pulse_h_30 0 5.044641e-9
Gw2_31_3 0 sum_o_3 pulse_h_31 0 -5.491941e-8
Gw2_32_3 0 sum_o_3 pulse_h_32 0 -1.035276e-8
Gw2_33_3 0 sum_o_3 pulse_h_33 0 7.420827e-8
Gw2_34_3 0 sum_o_3 pulse_h_34 0 -5.646111e-8
Gw2_35_3 0 sum_o_3 pulse_h_35 0 1.094991e-7
Gw2_36_3 0 sum_o_3 pulse_h_36 0 -1.667349e-8
Gw2_37_3 0 sum_o_3 pulse_h_37 0 3.815470e-8
Gw2_38_3 0 sum_o_3 pulse_h_38 0 1.326924e-7
Gw2_39_3 0 sum_o_3 pulse_h_39 0 -3.017580e-8
Gw2_40_3 0 sum_o_3 pulse_h_40 0 -1.802567e-7
Gw2_41_3 0 sum_o_3 pulse_h_41 0 7.024011e-8
Gw2_42_3 0 sum_o_3 pulse_h_42 0 -9.557030e-8
Gw2_43_3 0 sum_o_3 pulse_h_43 0 -2.811308e-8
Gw2_44_3 0 sum_o_3 pulse_h_44 0 1.438652e-8
Gw2_45_3 0 sum_o_3 pulse_h_45 0 7.628645e-8
Gw2_46_3 0 sum_o_3 pulse_h_46 0 8.769765e-8
Gw2_47_3 0 sum_o_3 pulse_h_47 0 -1.377603e-7
Gw2_48_3 0 sum_o_3 pulse_h_48 0 -7.916482e-8
Gw2_49_3 0 sum_o_3 pulse_h_49 0 -2.912932e-8
Gw2_50_3 0 sum_o_3 pulse_h_50 0 1.346745e-8
Gw2_51_3 0 sum_o_3 pulse_h_51 0 6.824215e-8
Gw2_52_3 0 sum_o_3 pulse_h_52 0 -3.118043e-8
Gw2_53_3 0 sum_o_3 pulse_h_53 0 1.468190e-7
Gw2_54_3 0 sum_o_3 pulse_h_54 0 -1.452590e-7
Gw2_55_3 0 sum_o_3 pulse_h_55 0 2.028121e-7
Gw2_56_3 0 sum_o_3 pulse_h_56 0 3.995688e-8
Gw2_57_3 0 sum_o_3 pulse_h_57 0 4.409061e-8
Gw2_58_3 0 sum_o_3 pulse_h_58 0 1.118997e-8
Gw2_59_3 0 sum_o_3 pulse_h_59 0 6.108209e-8
Gw2_60_3 0 sum_o_3 pulse_h_60 0 -1.584712e-7
Gw2_61_3 0 sum_o_3 pulse_h_61 0 9.548332e-8
Gw2_62_3 0 sum_o_3 pulse_h_62 0 1.477839e-8
Gw2_63_3 0 sum_o_3 pulse_h_63 0 8.977323e-8
Gw2_64_3 0 sum_o_3 pulse_h_64 0 4.585659e-8
Gw2_65_3 0 sum_o_3 pulse_h_65 0 -7.744307e-8
Gw2_66_3 0 sum_o_3 pulse_h_66 0 7.776488e-8
Gw2_67_3 0 sum_o_3 pulse_h_67 0 5.896867e-8
Gw2_68_3 0 sum_o_3 pulse_h_68 0 3.574792e-8
Gw2_69_3 0 sum_o_3 pulse_h_69 0 2.051042e-8
Gw2_70_3 0 sum_o_3 pulse_h_70 0 4.313379e-8
Gw2_71_3 0 sum_o_3 pulse_h_71 0 -2.370601e-8
Gw2_72_3 0 sum_o_3 pulse_h_72 0 1.199680e-8
Gw2_73_3 0 sum_o_3 pulse_h_73 0 -2.353065e-7
Gw2_74_3 0 sum_o_3 pulse_h_74 0 1.691212e-7
Gw2_75_3 0 sum_o_3 pulse_h_75 0 3.782224e-8
Gw2_76_3 0 sum_o_3 pulse_h_76 0 -1.744321e-7
Gw2_77_3 0 sum_o_3 pulse_h_77 0 -5.769310e-8
Gw2_78_3 0 sum_o_3 pulse_h_78 0 1.098632e-7
Gw2_79_3 0 sum_o_3 pulse_h_79 0 1.111681e-7
Gw2_80_3 0 sum_o_3 pulse_h_80 0 -7.638006e-8
Gw2_81_3 0 sum_o_3 pulse_h_81 0 -7.499703e-9
Gw2_82_3 0 sum_o_3 pulse_h_82 0 -6.741170e-8
Gw2_83_3 0 sum_o_3 pulse_h_83 0 -6.884731e-8
Gw2_84_3 0 sum_o_3 pulse_h_84 0 -2.025581e-8
Gw2_85_3 0 sum_o_3 pulse_h_85 0 -5.207336e-8
Gw2_86_3 0 sum_o_3 pulse_h_86 0 -1.036862e-7
Gw2_87_3 0 sum_o_3 pulse_h_87 0 -9.931517e-8
Gw2_88_3 0 sum_o_3 pulse_h_88 0 4.122627e-8
Gw2_89_3 0 sum_o_3 pulse_h_89 0 -1.021567e-7
Gw2_90_3 0 sum_o_3 pulse_h_90 0 2.360464e-9
Gw2_91_3 0 sum_o_3 pulse_h_91 0 4.551979e-8
Gw2_92_3 0 sum_o_3 pulse_h_92 0 6.160030e-8
Gw2_93_3 0 sum_o_3 pulse_h_93 0 2.373708e-8
Gw2_94_3 0 sum_o_3 pulse_h_94 0 -9.516165e-8
Gw2_95_3 0 sum_o_3 pulse_h_95 0 -6.225285e-8
Gw2_96_3 0 sum_o_3 pulse_h_96 0 6.563694e-8
Gw2_97_3 0 sum_o_3 pulse_h_97 0 8.202316e-9
Gw2_98_3 0 sum_o_3 pulse_h_98 0 2.457141e-7
Gw2_99_3 0 sum_o_3 pulse_h_99 0 -8.403811e-8
Gw2_0_4 0 sum_o_4 pulse_h_0 0 4.014836e-9
Gw2_1_4 0 sum_o_4 pulse_h_1 0 -7.395435e-9
Gw2_2_4 0 sum_o_4 pulse_h_2 0 -5.162173e-8
Gw2_3_4 0 sum_o_4 pulse_h_3 0 5.265900e-8
Gw2_4_4 0 sum_o_4 pulse_h_4 0 3.536866e-8
Gw2_5_4 0 sum_o_4 pulse_h_5 0 -8.356145e-8
Gw2_6_4 0 sum_o_4 pulse_h_6 0 -5.997634e-8
Gw2_7_4 0 sum_o_4 pulse_h_7 0 3.337501e-8
Gw2_8_4 0 sum_o_4 pulse_h_8 0 9.616998e-8
Gw2_9_4 0 sum_o_4 pulse_h_9 0 -1.666469e-7
Gw2_10_4 0 sum_o_4 pulse_h_10 0 6.627403e-10
Gw2_11_4 0 sum_o_4 pulse_h_11 0 1.905605e-8
Gw2_12_4 0 sum_o_4 pulse_h_12 0 3.080510e-8
Gw2_13_4 0 sum_o_4 pulse_h_13 0 -6.068996e-8
Gw2_14_4 0 sum_o_4 pulse_h_14 0 -9.673625e-8
Gw2_15_4 0 sum_o_4 pulse_h_15 0 4.714222e-8
Gw2_16_4 0 sum_o_4 pulse_h_16 0 -1.025630e-8
Gw2_17_4 0 sum_o_4 pulse_h_17 0 3.320214e-8
Gw2_18_4 0 sum_o_4 pulse_h_18 0 -1.077115e-7
Gw2_19_4 0 sum_o_4 pulse_h_19 0 -5.069065e-8
Gw2_20_4 0 sum_o_4 pulse_h_20 0 9.141569e-8
Gw2_21_4 0 sum_o_4 pulse_h_21 0 -4.033136e-8
Gw2_22_4 0 sum_o_4 pulse_h_22 0 1.546271e-7
Gw2_23_4 0 sum_o_4 pulse_h_23 0 -1.118282e-7
Gw2_24_4 0 sum_o_4 pulse_h_24 0 -7.007782e-8
Gw2_25_4 0 sum_o_4 pulse_h_25 0 7.815545e-8
Gw2_26_4 0 sum_o_4 pulse_h_26 0 5.603334e-8
Gw2_27_4 0 sum_o_4 pulse_h_27 0 9.421512e-8
Gw2_28_4 0 sum_o_4 pulse_h_28 0 8.411760e-8
Gw2_29_4 0 sum_o_4 pulse_h_29 0 -6.584516e-8
Gw2_30_4 0 sum_o_4 pulse_h_30 0 1.649454e-8
Gw2_31_4 0 sum_o_4 pulse_h_31 0 -3.487656e-8
Gw2_32_4 0 sum_o_4 pulse_h_32 0 7.894725e-8
Gw2_33_4 0 sum_o_4 pulse_h_33 0 9.100439e-8
Gw2_34_4 0 sum_o_4 pulse_h_34 0 2.609905e-7
Gw2_35_4 0 sum_o_4 pulse_h_35 0 7.842911e-8
Gw2_36_4 0 sum_o_4 pulse_h_36 0 -8.355656e-8
Gw2_37_4 0 sum_o_4 pulse_h_37 0 4.615272e-8
Gw2_38_4 0 sum_o_4 pulse_h_38 0 4.481712e-8
Gw2_39_4 0 sum_o_4 pulse_h_39 0 -5.750170e-8
Gw2_40_4 0 sum_o_4 pulse_h_40 0 -3.115848e-7
Gw2_41_4 0 sum_o_4 pulse_h_41 0 8.965352e-9
Gw2_42_4 0 sum_o_4 pulse_h_42 0 -2.573173e-7
Gw2_43_4 0 sum_o_4 pulse_h_43 0 3.542041e-8
Gw2_44_4 0 sum_o_4 pulse_h_44 0 5.203414e-8
Gw2_45_4 0 sum_o_4 pulse_h_45 0 8.484213e-8
Gw2_46_4 0 sum_o_4 pulse_h_46 0 -2.446244e-7
Gw2_47_4 0 sum_o_4 pulse_h_47 0 1.813520e-7
Gw2_48_4 0 sum_o_4 pulse_h_48 0 1.175939e-7
Gw2_49_4 0 sum_o_4 pulse_h_49 0 8.742884e-8
Gw2_50_4 0 sum_o_4 pulse_h_50 0 -9.296990e-8
Gw2_51_4 0 sum_o_4 pulse_h_51 0 -2.508818e-7
Gw2_52_4 0 sum_o_4 pulse_h_52 0 1.409330e-7
Gw2_53_4 0 sum_o_4 pulse_h_53 0 -8.639955e-9
Gw2_54_4 0 sum_o_4 pulse_h_54 0 -2.307641e-7
Gw2_55_4 0 sum_o_4 pulse_h_55 0 -1.971179e-7
Gw2_56_4 0 sum_o_4 pulse_h_56 0 -1.807093e-7
Gw2_57_4 0 sum_o_4 pulse_h_57 0 -5.504350e-8
Gw2_58_4 0 sum_o_4 pulse_h_58 0 5.808706e-8
Gw2_59_4 0 sum_o_4 pulse_h_59 0 -3.288697e-7
Gw2_60_4 0 sum_o_4 pulse_h_60 0 -1.285137e-7
Gw2_61_4 0 sum_o_4 pulse_h_61 0 -1.064041e-7
Gw2_62_4 0 sum_o_4 pulse_h_62 0 -5.796529e-8
Gw2_63_4 0 sum_o_4 pulse_h_63 0 -1.059131e-7
Gw2_64_4 0 sum_o_4 pulse_h_64 0 -7.222756e-8
Gw2_65_4 0 sum_o_4 pulse_h_65 0 4.550098e-8
Gw2_66_4 0 sum_o_4 pulse_h_66 0 1.131727e-7
Gw2_67_4 0 sum_o_4 pulse_h_67 0 -1.397073e-7
Gw2_68_4 0 sum_o_4 pulse_h_68 0 3.432562e-8
Gw2_69_4 0 sum_o_4 pulse_h_69 0 3.351106e-9
Gw2_70_4 0 sum_o_4 pulse_h_70 0 8.682308e-8
Gw2_71_4 0 sum_o_4 pulse_h_71 0 5.098692e-8
Gw2_72_4 0 sum_o_4 pulse_h_72 0 -2.015080e-8
Gw2_73_4 0 sum_o_4 pulse_h_73 0 1.959395e-7
Gw2_74_4 0 sum_o_4 pulse_h_74 0 -9.775803e-9
Gw2_75_4 0 sum_o_4 pulse_h_75 0 -2.139735e-7
Gw2_76_4 0 sum_o_4 pulse_h_76 0 -8.421070e-8
Gw2_77_4 0 sum_o_4 pulse_h_77 0 2.345057e-8
Gw2_78_4 0 sum_o_4 pulse_h_78 0 -5.974741e-8
Gw2_79_4 0 sum_o_4 pulse_h_79 0 -3.899538e-7
Gw2_80_4 0 sum_o_4 pulse_h_80 0 1.049089e-7
Gw2_81_4 0 sum_o_4 pulse_h_81 0 1.653794e-8
Gw2_82_4 0 sum_o_4 pulse_h_82 0 -7.977964e-9
Gw2_83_4 0 sum_o_4 pulse_h_83 0 -1.138515e-7
Gw2_84_4 0 sum_o_4 pulse_h_84 0 6.899144e-8
Gw2_85_4 0 sum_o_4 pulse_h_85 0 2.107106e-8
Gw2_86_4 0 sum_o_4 pulse_h_86 0 -5.695819e-8
Gw2_87_4 0 sum_o_4 pulse_h_87 0 6.646405e-8
Gw2_88_4 0 sum_o_4 pulse_h_88 0 -3.597208e-7
Gw2_89_4 0 sum_o_4 pulse_h_89 0 1.729353e-7
Gw2_90_4 0 sum_o_4 pulse_h_90 0 -7.940164e-8
Gw2_91_4 0 sum_o_4 pulse_h_91 0 1.517660e-7
Gw2_92_4 0 sum_o_4 pulse_h_92 0 3.601996e-8
Gw2_93_4 0 sum_o_4 pulse_h_93 0 -2.530753e-7
Gw2_94_4 0 sum_o_4 pulse_h_94 0 -1.193866e-7
Gw2_95_4 0 sum_o_4 pulse_h_95 0 4.793403e-9
Gw2_96_4 0 sum_o_4 pulse_h_96 0 5.655735e-9
Gw2_97_4 0 sum_o_4 pulse_h_97 0 4.630023e-8
Gw2_98_4 0 sum_o_4 pulse_h_98 0 -1.591233e-7
Gw2_99_4 0 sum_o_4 pulse_h_99 0 2.939005e-8
Gw2_0_5 0 sum_o_5 pulse_h_0 0 -1.466323e-7
Gw2_1_5 0 sum_o_5 pulse_h_1 0 -1.159974e-7
Gw2_2_5 0 sum_o_5 pulse_h_2 0 -6.319404e-8
Gw2_3_5 0 sum_o_5 pulse_h_3 0 -1.246829e-7
Gw2_4_5 0 sum_o_5 pulse_h_4 0 -8.164395e-8
Gw2_5_5 0 sum_o_5 pulse_h_5 0 1.892500e-8
Gw2_6_5 0 sum_o_5 pulse_h_6 0 -3.172378e-8
Gw2_7_5 0 sum_o_5 pulse_h_7 0 -1.617243e-7
Gw2_8_5 0 sum_o_5 pulse_h_8 0 1.608569e-7
Gw2_9_5 0 sum_o_5 pulse_h_9 0 7.900848e-9
Gw2_10_5 0 sum_o_5 pulse_h_10 0 5.955327e-8
Gw2_11_5 0 sum_o_5 pulse_h_11 0 1.189363e-7
Gw2_12_5 0 sum_o_5 pulse_h_12 0 -1.784104e-7
Gw2_13_5 0 sum_o_5 pulse_h_13 0 -5.709409e-8
Gw2_14_5 0 sum_o_5 pulse_h_14 0 6.842761e-8
Gw2_15_5 0 sum_o_5 pulse_h_15 0 3.885495e-8
Gw2_16_5 0 sum_o_5 pulse_h_16 0 3.056190e-8
Gw2_17_5 0 sum_o_5 pulse_h_17 0 -2.413622e-8
Gw2_18_5 0 sum_o_5 pulse_h_18 0 -9.993212e-8
Gw2_19_5 0 sum_o_5 pulse_h_19 0 1.238062e-7
Gw2_20_5 0 sum_o_5 pulse_h_20 0 6.771355e-8
Gw2_21_5 0 sum_o_5 pulse_h_21 0 -1.939935e-7
Gw2_22_5 0 sum_o_5 pulse_h_22 0 1.297854e-7
Gw2_23_5 0 sum_o_5 pulse_h_23 0 -7.408605e-9
Gw2_24_5 0 sum_o_5 pulse_h_24 0 -2.824994e-7
Gw2_25_5 0 sum_o_5 pulse_h_25 0 1.159383e-7
Gw2_26_5 0 sum_o_5 pulse_h_26 0 1.252886e-7
Gw2_27_5 0 sum_o_5 pulse_h_27 0 -9.849034e-8
Gw2_28_5 0 sum_o_5 pulse_h_28 0 -8.298632e-8
Gw2_29_5 0 sum_o_5 pulse_h_29 0 -6.670055e-9
Gw2_30_5 0 sum_o_5 pulse_h_30 0 -2.077682e-9
Gw2_31_5 0 sum_o_5 pulse_h_31 0 -8.574656e-8
Gw2_32_5 0 sum_o_5 pulse_h_32 0 9.371609e-8
Gw2_33_5 0 sum_o_5 pulse_h_33 0 -7.757271e-8
Gw2_34_5 0 sum_o_5 pulse_h_34 0 -2.548801e-7
Gw2_35_5 0 sum_o_5 pulse_h_35 0 -4.181627e-8
Gw2_36_5 0 sum_o_5 pulse_h_36 0 -3.553566e-8
Gw2_37_5 0 sum_o_5 pulse_h_37 0 1.326037e-7
Gw2_38_5 0 sum_o_5 pulse_h_38 0 -1.490807e-7
Gw2_39_5 0 sum_o_5 pulse_h_39 0 1.862403e-7
Gw2_40_5 0 sum_o_5 pulse_h_40 0 2.015032e-8
Gw2_41_5 0 sum_o_5 pulse_h_41 0 -1.254858e-8
Gw2_42_5 0 sum_o_5 pulse_h_42 0 -8.175286e-8
Gw2_43_5 0 sum_o_5 pulse_h_43 0 -3.593653e-8
Gw2_44_5 0 sum_o_5 pulse_h_44 0 -9.555191e-8
Gw2_45_5 0 sum_o_5 pulse_h_45 0 -1.377495e-7
Gw2_46_5 0 sum_o_5 pulse_h_46 0 1.901432e-8
Gw2_47_5 0 sum_o_5 pulse_h_47 0 -2.086454e-8
Gw2_48_5 0 sum_o_5 pulse_h_48 0 -4.970657e-8
Gw2_49_5 0 sum_o_5 pulse_h_49 0 3.558740e-9
Gw2_50_5 0 sum_o_5 pulse_h_50 0 1.006068e-8
Gw2_51_5 0 sum_o_5 pulse_h_51 0 2.140095e-7
Gw2_52_5 0 sum_o_5 pulse_h_52 0 3.909559e-8
Gw2_53_5 0 sum_o_5 pulse_h_53 0 9.667276e-8
Gw2_54_5 0 sum_o_5 pulse_h_54 0 6.555490e-8
Gw2_55_5 0 sum_o_5 pulse_h_55 0 2.523049e-8
Gw2_56_5 0 sum_o_5 pulse_h_56 0 -1.254422e-9
Gw2_57_5 0 sum_o_5 pulse_h_57 0 -1.076039e-8
Gw2_58_5 0 sum_o_5 pulse_h_58 0 -1.750106e-8
Gw2_59_5 0 sum_o_5 pulse_h_59 0 -3.636311e-9
Gw2_60_5 0 sum_o_5 pulse_h_60 0 1.146986e-7
Gw2_61_5 0 sum_o_5 pulse_h_61 0 2.425989e-8
Gw2_62_5 0 sum_o_5 pulse_h_62 0 1.330595e-7
Gw2_63_5 0 sum_o_5 pulse_h_63 0 -1.592495e-7
Gw2_64_5 0 sum_o_5 pulse_h_64 0 -4.699369e-8
Gw2_65_5 0 sum_o_5 pulse_h_65 0 -3.082168e-8
Gw2_66_5 0 sum_o_5 pulse_h_66 0 6.991903e-8
Gw2_67_5 0 sum_o_5 pulse_h_67 0 2.376523e-8
Gw2_68_5 0 sum_o_5 pulse_h_68 0 8.520520e-8
Gw2_69_5 0 sum_o_5 pulse_h_69 0 -7.304351e-8
Gw2_70_5 0 sum_o_5 pulse_h_70 0 -2.266887e-8
Gw2_71_5 0 sum_o_5 pulse_h_71 0 5.949110e-8
Gw2_72_5 0 sum_o_5 pulse_h_72 0 1.603094e-7
Gw2_73_5 0 sum_o_5 pulse_h_73 0 -7.938719e-8
Gw2_74_5 0 sum_o_5 pulse_h_74 0 2.474873e-8
Gw2_75_5 0 sum_o_5 pulse_h_75 0 -1.479459e-8
Gw2_76_5 0 sum_o_5 pulse_h_76 0 2.627112e-8
Gw2_77_5 0 sum_o_5 pulse_h_77 0 3.174013e-8
Gw2_78_5 0 sum_o_5 pulse_h_78 0 -1.459036e-7
Gw2_79_5 0 sum_o_5 pulse_h_79 0 1.184110e-7
Gw2_80_5 0 sum_o_5 pulse_h_80 0 -1.150154e-7
Gw2_81_5 0 sum_o_5 pulse_h_81 0 3.731004e-8
Gw2_82_5 0 sum_o_5 pulse_h_82 0 -1.093980e-7
Gw2_83_5 0 sum_o_5 pulse_h_83 0 7.496039e-8
Gw2_84_5 0 sum_o_5 pulse_h_84 0 -1.010779e-7
Gw2_85_5 0 sum_o_5 pulse_h_85 0 8.406361e-8
Gw2_86_5 0 sum_o_5 pulse_h_86 0 2.578975e-8
Gw2_87_5 0 sum_o_5 pulse_h_87 0 -2.995638e-8
Gw2_88_5 0 sum_o_5 pulse_h_88 0 3.585239e-9
Gw2_89_5 0 sum_o_5 pulse_h_89 0 -1.606691e-7
Gw2_90_5 0 sum_o_5 pulse_h_90 0 1.490997e-7
Gw2_91_5 0 sum_o_5 pulse_h_91 0 -2.441229e-8
Gw2_92_5 0 sum_o_5 pulse_h_92 0 6.166031e-8
Gw2_93_5 0 sum_o_5 pulse_h_93 0 4.411505e-8
Gw2_94_5 0 sum_o_5 pulse_h_94 0 8.703037e-8
Gw2_95_5 0 sum_o_5 pulse_h_95 0 -8.876015e-8
Gw2_96_5 0 sum_o_5 pulse_h_96 0 8.811024e-8
Gw2_97_5 0 sum_o_5 pulse_h_97 0 9.530901e-8
Gw2_98_5 0 sum_o_5 pulse_h_98 0 1.197408e-7
Gw2_99_5 0 sum_o_5 pulse_h_99 0 3.952172e-8
Gw2_0_6 0 sum_o_6 pulse_h_0 0 -4.943875e-8
Gw2_1_6 0 sum_o_6 pulse_h_1 0 -5.505989e-8
Gw2_2_6 0 sum_o_6 pulse_h_2 0 -1.200053e-7
Gw2_3_6 0 sum_o_6 pulse_h_3 0 6.201456e-8
Gw2_4_6 0 sum_o_6 pulse_h_4 0 -1.408463e-7
Gw2_5_6 0 sum_o_6 pulse_h_5 0 -2.883574e-8
Gw2_6_6 0 sum_o_6 pulse_h_6 0 -5.210564e-8
Gw2_7_6 0 sum_o_6 pulse_h_7 0 -2.488962e-8
Gw2_8_6 0 sum_o_6 pulse_h_8 0 -8.044353e-11
Gw2_9_6 0 sum_o_6 pulse_h_9 0 -1.662053e-7
Gw2_10_6 0 sum_o_6 pulse_h_10 0 1.941331e-10
Gw2_11_6 0 sum_o_6 pulse_h_11 0 7.534888e-8
Gw2_12_6 0 sum_o_6 pulse_h_12 0 -4.585345e-9
Gw2_13_6 0 sum_o_6 pulse_h_13 0 -7.091457e-8
Gw2_14_6 0 sum_o_6 pulse_h_14 0 3.867144e-8
Gw2_15_6 0 sum_o_6 pulse_h_15 0 6.076005e-8
Gw2_16_6 0 sum_o_6 pulse_h_16 0 2.783213e-8
Gw2_17_6 0 sum_o_6 pulse_h_17 0 -1.232803e-7
Gw2_18_6 0 sum_o_6 pulse_h_18 0 -7.872716e-8
Gw2_19_6 0 sum_o_6 pulse_h_19 0 -2.022941e-7
Gw2_20_6 0 sum_o_6 pulse_h_20 0 -1.454331e-7
Gw2_21_6 0 sum_o_6 pulse_h_21 0 -2.901562e-7
Gw2_22_6 0 sum_o_6 pulse_h_22 0 9.479957e-8
Gw2_23_6 0 sum_o_6 pulse_h_23 0 -3.528686e-8
Gw2_24_6 0 sum_o_6 pulse_h_24 0 -1.205836e-7
Gw2_25_6 0 sum_o_6 pulse_h_25 0 1.174351e-7
Gw2_26_6 0 sum_o_6 pulse_h_26 0 1.205804e-8
Gw2_27_6 0 sum_o_6 pulse_h_27 0 4.275289e-9
Gw2_28_6 0 sum_o_6 pulse_h_28 0 -1.212544e-7
Gw2_29_6 0 sum_o_6 pulse_h_29 0 9.272068e-8
Gw2_30_6 0 sum_o_6 pulse_h_30 0 -7.015960e-8
Gw2_31_6 0 sum_o_6 pulse_h_31 0 6.715717e-8
Gw2_32_6 0 sum_o_6 pulse_h_32 0 -1.671066e-8
Gw2_33_6 0 sum_o_6 pulse_h_33 0 -1.250486e-8
Gw2_34_6 0 sum_o_6 pulse_h_34 0 -1.620623e-7
Gw2_35_6 0 sum_o_6 pulse_h_35 0 -1.217622e-8
Gw2_36_6 0 sum_o_6 pulse_h_36 0 2.804393e-8
Gw2_37_6 0 sum_o_6 pulse_h_37 0 1.877538e-8
Gw2_38_6 0 sum_o_6 pulse_h_38 0 -4.827511e-8
Gw2_39_6 0 sum_o_6 pulse_h_39 0 2.145871e-8
Gw2_40_6 0 sum_o_6 pulse_h_40 0 9.655309e-9
Gw2_41_6 0 sum_o_6 pulse_h_41 0 -5.775245e-8
Gw2_42_6 0 sum_o_6 pulse_h_42 0 4.330252e-9
Gw2_43_6 0 sum_o_6 pulse_h_43 0 9.068484e-8
Gw2_44_6 0 sum_o_6 pulse_h_44 0 -3.152398e-8
Gw2_45_6 0 sum_o_6 pulse_h_45 0 4.145398e-8
Gw2_46_6 0 sum_o_6 pulse_h_46 0 8.577926e-8
Gw2_47_6 0 sum_o_6 pulse_h_47 0 1.148450e-8
Gw2_48_6 0 sum_o_6 pulse_h_48 0 -4.919888e-8
Gw2_49_6 0 sum_o_6 pulse_h_49 0 6.000052e-8
Gw2_50_6 0 sum_o_6 pulse_h_50 0 1.037016e-7
Gw2_51_6 0 sum_o_6 pulse_h_51 0 1.463752e-7
Gw2_52_6 0 sum_o_6 pulse_h_52 0 4.802579e-8
Gw2_53_6 0 sum_o_6 pulse_h_53 0 -2.263527e-7
Gw2_54_6 0 sum_o_6 pulse_h_54 0 9.375269e-8
Gw2_55_6 0 sum_o_6 pulse_h_55 0 9.579918e-8
Gw2_56_6 0 sum_o_6 pulse_h_56 0 -6.827985e-8
Gw2_57_6 0 sum_o_6 pulse_h_57 0 6.675544e-8
Gw2_58_6 0 sum_o_6 pulse_h_58 0 3.092862e-8
Gw2_59_6 0 sum_o_6 pulse_h_59 0 4.803707e-8
Gw2_60_6 0 sum_o_6 pulse_h_60 0 1.292971e-7
Gw2_61_6 0 sum_o_6 pulse_h_61 0 9.224455e-9
Gw2_62_6 0 sum_o_6 pulse_h_62 0 6.154448e-8
Gw2_63_6 0 sum_o_6 pulse_h_63 0 -1.135555e-7
Gw2_64_6 0 sum_o_6 pulse_h_64 0 7.484904e-8
Gw2_65_6 0 sum_o_6 pulse_h_65 0 -6.141385e-8
Gw2_66_6 0 sum_o_6 pulse_h_66 0 7.703284e-8
Gw2_67_6 0 sum_o_6 pulse_h_67 0 1.868494e-7
Gw2_68_6 0 sum_o_6 pulse_h_68 0 6.179400e-8
Gw2_69_6 0 sum_o_6 pulse_h_69 0 1.305191e-8
Gw2_70_6 0 sum_o_6 pulse_h_70 0 6.294326e-8
Gw2_71_6 0 sum_o_6 pulse_h_71 0 6.094511e-8
Gw2_72_6 0 sum_o_6 pulse_h_72 0 -8.045659e-8
Gw2_73_6 0 sum_o_6 pulse_h_73 0 5.398602e-8
Gw2_74_6 0 sum_o_6 pulse_h_74 0 -4.758674e-8
Gw2_75_6 0 sum_o_6 pulse_h_75 0 -1.668903e-8
Gw2_76_6 0 sum_o_6 pulse_h_76 0 -8.720399e-8
Gw2_77_6 0 sum_o_6 pulse_h_77 0 8.481430e-8
Gw2_78_6 0 sum_o_6 pulse_h_78 0 -7.838175e-8
Gw2_79_6 0 sum_o_6 pulse_h_79 0 1.887787e-7
Gw2_80_6 0 sum_o_6 pulse_h_80 0 -7.775068e-8
Gw2_81_6 0 sum_o_6 pulse_h_81 0 -1.787181e-8
Gw2_82_6 0 sum_o_6 pulse_h_82 0 1.114410e-7
Gw2_83_6 0 sum_o_6 pulse_h_83 0 1.389583e-7
Gw2_84_6 0 sum_o_6 pulse_h_84 0 -1.595912e-8
Gw2_85_6 0 sum_o_6 pulse_h_85 0 -8.750184e-8
Gw2_86_6 0 sum_o_6 pulse_h_86 0 2.039318e-7
Gw2_87_6 0 sum_o_6 pulse_h_87 0 3.408147e-8
Gw2_88_6 0 sum_o_6 pulse_h_88 0 4.984499e-8
Gw2_89_6 0 sum_o_6 pulse_h_89 0 8.354385e-8
Gw2_90_6 0 sum_o_6 pulse_h_90 0 -2.486890e-8
Gw2_91_6 0 sum_o_6 pulse_h_91 0 1.831351e-7
Gw2_92_6 0 sum_o_6 pulse_h_92 0 -1.170922e-7
Gw2_93_6 0 sum_o_6 pulse_h_93 0 2.102906e-8
Gw2_94_6 0 sum_o_6 pulse_h_94 0 -1.697248e-9
Gw2_95_6 0 sum_o_6 pulse_h_95 0 -1.446359e-8
Gw2_96_6 0 sum_o_6 pulse_h_96 0 -1.095181e-7
Gw2_97_6 0 sum_o_6 pulse_h_97 0 -1.186507e-7
Gw2_98_6 0 sum_o_6 pulse_h_98 0 6.092618e-9
Gw2_99_6 0 sum_o_6 pulse_h_99 0 8.415319e-8
Gw2_0_7 0 sum_o_7 pulse_h_0 0 -2.468799e-8
Gw2_1_7 0 sum_o_7 pulse_h_1 0 -6.797352e-8
Gw2_2_7 0 sum_o_7 pulse_h_2 0 1.155177e-7
Gw2_3_7 0 sum_o_7 pulse_h_3 0 4.434007e-9
Gw2_4_7 0 sum_o_7 pulse_h_4 0 1.412193e-7
Gw2_5_7 0 sum_o_7 pulse_h_5 0 8.130953e-8
Gw2_6_7 0 sum_o_7 pulse_h_6 0 3.272863e-8
Gw2_7_7 0 sum_o_7 pulse_h_7 0 1.295420e-7
Gw2_8_7 0 sum_o_7 pulse_h_8 0 -1.572839e-7
Gw2_9_7 0 sum_o_7 pulse_h_9 0 1.098074e-7
Gw2_10_7 0 sum_o_7 pulse_h_10 0 -7.986294e-8
Gw2_11_7 0 sum_o_7 pulse_h_11 0 -7.368665e-9
Gw2_12_7 0 sum_o_7 pulse_h_12 0 1.262358e-7
Gw2_13_7 0 sum_o_7 pulse_h_13 0 6.067008e-8
Gw2_14_7 0 sum_o_7 pulse_h_14 0 -1.001916e-7
Gw2_15_7 0 sum_o_7 pulse_h_15 0 -1.887501e-7
Gw2_16_7 0 sum_o_7 pulse_h_16 0 1.226438e-8
Gw2_17_7 0 sum_o_7 pulse_h_17 0 5.651181e-8
Gw2_18_7 0 sum_o_7 pulse_h_18 0 3.531215e-8
Gw2_19_7 0 sum_o_7 pulse_h_19 0 4.284078e-8
Gw2_20_7 0 sum_o_7 pulse_h_20 0 1.426448e-7
Gw2_21_7 0 sum_o_7 pulse_h_21 0 1.884658e-7
Gw2_22_7 0 sum_o_7 pulse_h_22 0 3.791564e-8
Gw2_23_7 0 sum_o_7 pulse_h_23 0 4.336700e-8
Gw2_24_7 0 sum_o_7 pulse_h_24 0 2.244448e-8
Gw2_25_7 0 sum_o_7 pulse_h_25 0 1.664049e-8
Gw2_26_7 0 sum_o_7 pulse_h_26 0 4.620139e-8
Gw2_27_7 0 sum_o_7 pulse_h_27 0 3.746802e-8
Gw2_28_7 0 sum_o_7 pulse_h_28 0 1.247232e-7
Gw2_29_7 0 sum_o_7 pulse_h_29 0 5.133700e-9
Gw2_30_7 0 sum_o_7 pulse_h_30 0 2.524181e-8
Gw2_31_7 0 sum_o_7 pulse_h_31 0 2.607629e-8
Gw2_32_7 0 sum_o_7 pulse_h_32 0 -6.102383e-8
Gw2_33_7 0 sum_o_7 pulse_h_33 0 9.314935e-9
Gw2_34_7 0 sum_o_7 pulse_h_34 0 4.755476e-9
Gw2_35_7 0 sum_o_7 pulse_h_35 0 1.332422e-8
Gw2_36_7 0 sum_o_7 pulse_h_36 0 -1.640641e-7
Gw2_37_7 0 sum_o_7 pulse_h_37 0 -7.778022e-8
Gw2_38_7 0 sum_o_7 pulse_h_38 0 6.584961e-8
Gw2_39_7 0 sum_o_7 pulse_h_39 0 -1.884493e-7
Gw2_40_7 0 sum_o_7 pulse_h_40 0 9.204260e-8
Gw2_41_7 0 sum_o_7 pulse_h_41 0 -2.019795e-8
Gw2_42_7 0 sum_o_7 pulse_h_42 0 -4.100412e-8
Gw2_43_7 0 sum_o_7 pulse_h_43 0 -1.431407e-8
Gw2_44_7 0 sum_o_7 pulse_h_44 0 -4.317009e-9
Gw2_45_7 0 sum_o_7 pulse_h_45 0 4.824256e-8
Gw2_46_7 0 sum_o_7 pulse_h_46 0 -6.076827e-8
Gw2_47_7 0 sum_o_7 pulse_h_47 0 8.766732e-8
Gw2_48_7 0 sum_o_7 pulse_h_48 0 1.013410e-7
Gw2_49_7 0 sum_o_7 pulse_h_49 0 -2.359921e-8
Gw2_50_7 0 sum_o_7 pulse_h_50 0 -8.054648e-8
Gw2_51_7 0 sum_o_7 pulse_h_51 0 3.910293e-8
Gw2_52_7 0 sum_o_7 pulse_h_52 0 5.613380e-8
Gw2_53_7 0 sum_o_7 pulse_h_53 0 1.066758e-7
Gw2_54_7 0 sum_o_7 pulse_h_54 0 -7.710458e-8
Gw2_55_7 0 sum_o_7 pulse_h_55 0 -1.393536e-7
Gw2_56_7 0 sum_o_7 pulse_h_56 0 2.729081e-8
Gw2_57_7 0 sum_o_7 pulse_h_57 0 5.816856e-8
Gw2_58_7 0 sum_o_7 pulse_h_58 0 1.933206e-7
Gw2_59_7 0 sum_o_7 pulse_h_59 0 8.214571e-8
Gw2_60_7 0 sum_o_7 pulse_h_60 0 -3.296421e-8
Gw2_61_7 0 sum_o_7 pulse_h_61 0 2.657941e-8
Gw2_62_7 0 sum_o_7 pulse_h_62 0 -1.194670e-7
Gw2_63_7 0 sum_o_7 pulse_h_63 0 1.180612e-8
Gw2_64_7 0 sum_o_7 pulse_h_64 0 -1.248342e-7
Gw2_65_7 0 sum_o_7 pulse_h_65 0 2.772816e-8
Gw2_66_7 0 sum_o_7 pulse_h_66 0 -7.733154e-8
Gw2_67_7 0 sum_o_7 pulse_h_67 0 -9.437025e-8
Gw2_68_7 0 sum_o_7 pulse_h_68 0 -4.929598e-8
Gw2_69_7 0 sum_o_7 pulse_h_69 0 1.745327e-8
Gw2_70_7 0 sum_o_7 pulse_h_70 0 7.457835e-8
Gw2_71_7 0 sum_o_7 pulse_h_71 0 -6.596392e-8
Gw2_72_7 0 sum_o_7 pulse_h_72 0 -3.986785e-8
Gw2_73_7 0 sum_o_7 pulse_h_73 0 1.032300e-7
Gw2_74_7 0 sum_o_7 pulse_h_74 0 3.197633e-8
Gw2_75_7 0 sum_o_7 pulse_h_75 0 6.510261e-8
Gw2_76_7 0 sum_o_7 pulse_h_76 0 -4.284791e-8
Gw2_77_7 0 sum_o_7 pulse_h_77 0 7.803924e-8
Gw2_78_7 0 sum_o_7 pulse_h_78 0 -2.367674e-8
Gw2_79_7 0 sum_o_7 pulse_h_79 0 -1.064983e-7
Gw2_80_7 0 sum_o_7 pulse_h_80 0 -5.623475e-9
Gw2_81_7 0 sum_o_7 pulse_h_81 0 6.129969e-8
Gw2_82_7 0 sum_o_7 pulse_h_82 0 2.230503e-8
Gw2_83_7 0 sum_o_7 pulse_h_83 0 9.210731e-8
Gw2_84_7 0 sum_o_7 pulse_h_84 0 -3.526582e-8
Gw2_85_7 0 sum_o_7 pulse_h_85 0 1.204725e-8
Gw2_86_7 0 sum_o_7 pulse_h_86 0 -1.991144e-7
Gw2_87_7 0 sum_o_7 pulse_h_87 0 -5.952144e-8
Gw2_88_7 0 sum_o_7 pulse_h_88 0 9.988261e-8
Gw2_89_7 0 sum_o_7 pulse_h_89 0 1.619915e-8
Gw2_90_7 0 sum_o_7 pulse_h_90 0 -6.069114e-8
Gw2_91_7 0 sum_o_7 pulse_h_91 0 9.583201e-9
Gw2_92_7 0 sum_o_7 pulse_h_92 0 1.304104e-7
Gw2_93_7 0 sum_o_7 pulse_h_93 0 -2.255008e-7
Gw2_94_7 0 sum_o_7 pulse_h_94 0 -4.110268e-8
Gw2_95_7 0 sum_o_7 pulse_h_95 0 -1.519101e-8
Gw2_96_7 0 sum_o_7 pulse_h_96 0 2.340906e-8
Gw2_97_7 0 sum_o_7 pulse_h_97 0 -2.664334e-8
Gw2_98_7 0 sum_o_7 pulse_h_98 0 -1.356195e-7
Gw2_99_7 0 sum_o_7 pulse_h_99 0 -8.291667e-8
Gw2_0_8 0 sum_o_8 pulse_h_0 0 1.185698e-7
Gw2_1_8 0 sum_o_8 pulse_h_1 0 6.914640e-8
Gw2_2_8 0 sum_o_8 pulse_h_2 0 -3.273950e-7
Gw2_3_8 0 sum_o_8 pulse_h_3 0 1.826145e-8
Gw2_4_8 0 sum_o_8 pulse_h_4 0 -1.279906e-7
Gw2_5_8 0 sum_o_8 pulse_h_5 0 -1.946693e-8
Gw2_6_8 0 sum_o_8 pulse_h_6 0 6.732834e-8
Gw2_7_8 0 sum_o_8 pulse_h_7 0 -8.724767e-8
Gw2_8_8 0 sum_o_8 pulse_h_8 0 3.950019e-9
Gw2_9_8 0 sum_o_8 pulse_h_9 0 -2.263227e-7
Gw2_10_8 0 sum_o_8 pulse_h_10 0 4.289825e-8
Gw2_11_8 0 sum_o_8 pulse_h_11 0 4.529752e-8
Gw2_12_8 0 sum_o_8 pulse_h_12 0 3.273392e-8
Gw2_13_8 0 sum_o_8 pulse_h_13 0 -8.357695e-8
Gw2_14_8 0 sum_o_8 pulse_h_14 0 1.181504e-7
Gw2_15_8 0 sum_o_8 pulse_h_15 0 -1.124488e-7
Gw2_16_8 0 sum_o_8 pulse_h_16 0 -7.218289e-8
Gw2_17_8 0 sum_o_8 pulse_h_17 0 9.339701e-8
Gw2_18_8 0 sum_o_8 pulse_h_18 0 7.230052e-8
Gw2_19_8 0 sum_o_8 pulse_h_19 0 -7.552728e-8
Gw2_20_8 0 sum_o_8 pulse_h_20 0 4.105814e-8
Gw2_21_8 0 sum_o_8 pulse_h_21 0 -7.534278e-8
Gw2_22_8 0 sum_o_8 pulse_h_22 0 -1.949443e-8
Gw2_23_8 0 sum_o_8 pulse_h_23 0 -1.795826e-7
Gw2_24_8 0 sum_o_8 pulse_h_24 0 2.036273e-8
Gw2_25_8 0 sum_o_8 pulse_h_25 0 -9.809130e-9
Gw2_26_8 0 sum_o_8 pulse_h_26 0 1.474950e-7
Gw2_27_8 0 sum_o_8 pulse_h_27 0 3.338134e-8
Gw2_28_8 0 sum_o_8 pulse_h_28 0 -1.280048e-7
Gw2_29_8 0 sum_o_8 pulse_h_29 0 1.330825e-7
Gw2_30_8 0 sum_o_8 pulse_h_30 0 -1.197357e-7
Gw2_31_8 0 sum_o_8 pulse_h_31 0 -4.717668e-8
Gw2_32_8 0 sum_o_8 pulse_h_32 0 1.016168e-7
Gw2_33_8 0 sum_o_8 pulse_h_33 0 1.661496e-8
Gw2_34_8 0 sum_o_8 pulse_h_34 0 -3.821622e-8
Gw2_35_8 0 sum_o_8 pulse_h_35 0 8.061166e-8
Gw2_36_8 0 sum_o_8 pulse_h_36 0 -1.016549e-7
Gw2_37_8 0 sum_o_8 pulse_h_37 0 1.100799e-7
Gw2_38_8 0 sum_o_8 pulse_h_38 0 -1.449973e-8
Gw2_39_8 0 sum_o_8 pulse_h_39 0 -8.548381e-9
Gw2_40_8 0 sum_o_8 pulse_h_40 0 -8.600652e-8
Gw2_41_8 0 sum_o_8 pulse_h_41 0 -1.000836e-7
Gw2_42_8 0 sum_o_8 pulse_h_42 0 -1.320880e-7
Gw2_43_8 0 sum_o_8 pulse_h_43 0 -2.331164e-8
Gw2_44_8 0 sum_o_8 pulse_h_44 0 1.207834e-7
Gw2_45_8 0 sum_o_8 pulse_h_45 0 -4.828350e-8
Gw2_46_8 0 sum_o_8 pulse_h_46 0 2.470493e-8
Gw2_47_8 0 sum_o_8 pulse_h_47 0 -1.859920e-7
Gw2_48_8 0 sum_o_8 pulse_h_48 0 -9.691529e-8
Gw2_49_8 0 sum_o_8 pulse_h_49 0 -7.421904e-9
Gw2_50_8 0 sum_o_8 pulse_h_50 0 -7.915507e-8
Gw2_51_8 0 sum_o_8 pulse_h_51 0 6.231214e-8
Gw2_52_8 0 sum_o_8 pulse_h_52 0 4.119093e-8
Gw2_53_8 0 sum_o_8 pulse_h_53 0 8.807277e-8
Gw2_54_8 0 sum_o_8 pulse_h_54 0 -3.973306e-8
Gw2_55_8 0 sum_o_8 pulse_h_55 0 -8.170704e-8
Gw2_56_8 0 sum_o_8 pulse_h_56 0 6.643209e-8
Gw2_57_8 0 sum_o_8 pulse_h_57 0 -3.080305e-8
Gw2_58_8 0 sum_o_8 pulse_h_58 0 -2.520027e-7
Gw2_59_8 0 sum_o_8 pulse_h_59 0 -1.548620e-7
Gw2_60_8 0 sum_o_8 pulse_h_60 0 -8.298792e-8
Gw2_61_8 0 sum_o_8 pulse_h_61 0 -6.169880e-8
Gw2_62_8 0 sum_o_8 pulse_h_62 0 4.134898e-8
Gw2_63_8 0 sum_o_8 pulse_h_63 0 7.782676e-8
Gw2_64_8 0 sum_o_8 pulse_h_64 0 6.851776e-8
Gw2_65_8 0 sum_o_8 pulse_h_65 0 9.292572e-8
Gw2_66_8 0 sum_o_8 pulse_h_66 0 1.144271e-8
Gw2_67_8 0 sum_o_8 pulse_h_67 0 2.441890e-8
Gw2_68_8 0 sum_o_8 pulse_h_68 0 -3.085697e-8
Gw2_69_8 0 sum_o_8 pulse_h_69 0 2.197198e-8
Gw2_70_8 0 sum_o_8 pulse_h_70 0 1.661839e-9
Gw2_71_8 0 sum_o_8 pulse_h_71 0 -7.037738e-8
Gw2_72_8 0 sum_o_8 pulse_h_72 0 2.010301e-8
Gw2_73_8 0 sum_o_8 pulse_h_73 0 5.661024e-8
Gw2_74_8 0 sum_o_8 pulse_h_74 0 -7.276015e-8
Gw2_75_8 0 sum_o_8 pulse_h_75 0 4.196326e-8
Gw2_76_8 0 sum_o_8 pulse_h_76 0 5.301726e-8
Gw2_77_8 0 sum_o_8 pulse_h_77 0 -3.554824e-8
Gw2_78_8 0 sum_o_8 pulse_h_78 0 -5.930270e-8
Gw2_79_8 0 sum_o_8 pulse_h_79 0 -1.814074e-8
Gw2_80_8 0 sum_o_8 pulse_h_80 0 -1.342362e-7
Gw2_81_8 0 sum_o_8 pulse_h_81 0 1.117428e-7
Gw2_82_8 0 sum_o_8 pulse_h_82 0 8.700489e-8
Gw2_83_8 0 sum_o_8 pulse_h_83 0 2.885065e-8
Gw2_84_8 0 sum_o_8 pulse_h_84 0 -1.289850e-8
Gw2_85_8 0 sum_o_8 pulse_h_85 0 -1.266842e-8
Gw2_86_8 0 sum_o_8 pulse_h_86 0 -2.301256e-8
Gw2_87_8 0 sum_o_8 pulse_h_87 0 -1.256029e-7
Gw2_88_8 0 sum_o_8 pulse_h_88 0 -1.306774e-7
Gw2_89_8 0 sum_o_8 pulse_h_89 0 -1.449024e-7
Gw2_90_8 0 sum_o_8 pulse_h_90 0 5.711636e-8
Gw2_91_8 0 sum_o_8 pulse_h_91 0 -7.160011e-8
Gw2_92_8 0 sum_o_8 pulse_h_92 0 -1.047235e-7
Gw2_93_8 0 sum_o_8 pulse_h_93 0 9.284030e-9
Gw2_94_8 0 sum_o_8 pulse_h_94 0 -5.383006e-8
Gw2_95_8 0 sum_o_8 pulse_h_95 0 3.500207e-8
Gw2_96_8 0 sum_o_8 pulse_h_96 0 6.867415e-8
Gw2_97_8 0 sum_o_8 pulse_h_97 0 -9.764388e-8
Gw2_98_8 0 sum_o_8 pulse_h_98 0 -3.083778e-8
Gw2_99_8 0 sum_o_8 pulse_h_99 0 8.024836e-8
Gw2_0_9 0 sum_o_9 pulse_h_0 0 -1.259539e-8
Gw2_1_9 0 sum_o_9 pulse_h_1 0 4.501016e-8
Gw2_2_9 0 sum_o_9 pulse_h_2 0 -9.805638e-8
Gw2_3_9 0 sum_o_9 pulse_h_3 0 1.370212e-7
Gw2_4_9 0 sum_o_9 pulse_h_4 0 6.532478e-8
Gw2_5_9 0 sum_o_9 pulse_h_5 0 -7.776577e-8
Gw2_6_9 0 sum_o_9 pulse_h_6 0 9.706334e-8
Gw2_7_9 0 sum_o_9 pulse_h_7 0 6.237106e-8
Gw2_8_9 0 sum_o_9 pulse_h_8 0 7.322549e-8
Gw2_9_9 0 sum_o_9 pulse_h_9 0 9.301130e-8
Gw2_10_9 0 sum_o_9 pulse_h_10 0 1.342487e-7
Gw2_11_9 0 sum_o_9 pulse_h_11 0 1.958554e-8
Gw2_12_9 0 sum_o_9 pulse_h_12 0 -2.479549e-9
Gw2_13_9 0 sum_o_9 pulse_h_13 0 1.066278e-7
Gw2_14_9 0 sum_o_9 pulse_h_14 0 1.193366e-7
Gw2_15_9 0 sum_o_9 pulse_h_15 0 -8.443924e-8
Gw2_16_9 0 sum_o_9 pulse_h_16 0 -3.926434e-8
Gw2_17_9 0 sum_o_9 pulse_h_17 0 -7.268029e-8
Gw2_18_9 0 sum_o_9 pulse_h_18 0 -1.308797e-8
Gw2_19_9 0 sum_o_9 pulse_h_19 0 -1.843809e-7
Gw2_20_9 0 sum_o_9 pulse_h_20 0 -7.042016e-8
Gw2_21_9 0 sum_o_9 pulse_h_21 0 -1.147172e-7
Gw2_22_9 0 sum_o_9 pulse_h_22 0 1.301899e-7
Gw2_23_9 0 sum_o_9 pulse_h_23 0 1.391565e-7
Gw2_24_9 0 sum_o_9 pulse_h_24 0 2.885946e-8
Gw2_25_9 0 sum_o_9 pulse_h_25 0 1.021994e-7
Gw2_26_9 0 sum_o_9 pulse_h_26 0 -1.298607e-7
Gw2_27_9 0 sum_o_9 pulse_h_27 0 1.510818e-8
Gw2_28_9 0 sum_o_9 pulse_h_28 0 5.075039e-8
Gw2_29_9 0 sum_o_9 pulse_h_29 0 -2.110114e-7
Gw2_30_9 0 sum_o_9 pulse_h_30 0 -2.883344e-9
Gw2_31_9 0 sum_o_9 pulse_h_31 0 -1.829058e-7
Gw2_32_9 0 sum_o_9 pulse_h_32 0 9.638333e-9
Gw2_33_9 0 sum_o_9 pulse_h_33 0 -1.645798e-7
Gw2_34_9 0 sum_o_9 pulse_h_34 0 -1.071885e-7
Gw2_35_9 0 sum_o_9 pulse_h_35 0 2.583972e-8
Gw2_36_9 0 sum_o_9 pulse_h_36 0 2.534311e-8
Gw2_37_9 0 sum_o_9 pulse_h_37 0 -9.740291e-8
Gw2_38_9 0 sum_o_9 pulse_h_38 0 1.686667e-7
Gw2_39_9 0 sum_o_9 pulse_h_39 0 -3.695721e-8
Gw2_40_9 0 sum_o_9 pulse_h_40 0 -5.518174e-8
Gw2_41_9 0 sum_o_9 pulse_h_41 0 5.198308e-8
Gw2_42_9 0 sum_o_9 pulse_h_42 0 6.773179e-8
Gw2_43_9 0 sum_o_9 pulse_h_43 0 -1.767552e-7
Gw2_44_9 0 sum_o_9 pulse_h_44 0 1.093227e-7
Gw2_45_9 0 sum_o_9 pulse_h_45 0 -3.017901e-7
Gw2_46_9 0 sum_o_9 pulse_h_46 0 -1.497934e-7
Gw2_47_9 0 sum_o_9 pulse_h_47 0 6.997639e-8
Gw2_48_9 0 sum_o_9 pulse_h_48 0 -1.144722e-7
Gw2_49_9 0 sum_o_9 pulse_h_49 0 4.337797e-8
Gw2_50_9 0 sum_o_9 pulse_h_50 0 -7.738671e-8
Gw2_51_9 0 sum_o_9 pulse_h_51 0 -1.139154e-8
Gw2_52_9 0 sum_o_9 pulse_h_52 0 1.089475e-7
Gw2_53_9 0 sum_o_9 pulse_h_53 0 1.162660e-7
Gw2_54_9 0 sum_o_9 pulse_h_54 0 -7.938141e-8
Gw2_55_9 0 sum_o_9 pulse_h_55 0 -8.838127e-8
Gw2_56_9 0 sum_o_9 pulse_h_56 0 1.031654e-8
Gw2_57_9 0 sum_o_9 pulse_h_57 0 -3.332462e-8
Gw2_58_9 0 sum_o_9 pulse_h_58 0 3.544108e-8
Gw2_59_9 0 sum_o_9 pulse_h_59 0 -1.815929e-7
Gw2_60_9 0 sum_o_9 pulse_h_60 0 -1.114965e-7
Gw2_61_9 0 sum_o_9 pulse_h_61 0 2.622284e-8
Gw2_62_9 0 sum_o_9 pulse_h_62 0 8.528320e-8
Gw2_63_9 0 sum_o_9 pulse_h_63 0 5.342891e-8
Gw2_64_9 0 sum_o_9 pulse_h_64 0 1.941948e-8
Gw2_65_9 0 sum_o_9 pulse_h_65 0 -2.938140e-8
Gw2_66_9 0 sum_o_9 pulse_h_66 0 2.713946e-8
Gw2_67_9 0 sum_o_9 pulse_h_67 0 -1.773118e-7
Gw2_68_9 0 sum_o_9 pulse_h_68 0 -5.244458e-8
Gw2_69_9 0 sum_o_9 pulse_h_69 0 6.702101e-8
Gw2_70_9 0 sum_o_9 pulse_h_70 0 2.794237e-8
Gw2_71_9 0 sum_o_9 pulse_h_71 0 8.037750e-8
Gw2_72_9 0 sum_o_9 pulse_h_72 0 4.145986e-8
Gw2_73_9 0 sum_o_9 pulse_h_73 0 -1.598719e-7
Gw2_74_9 0 sum_o_9 pulse_h_74 0 1.277838e-7
Gw2_75_9 0 sum_o_9 pulse_h_75 0 -6.475176e-8
Gw2_76_9 0 sum_o_9 pulse_h_76 0 -2.698626e-8
Gw2_77_9 0 sum_o_9 pulse_h_77 0 8.324830e-8
Gw2_78_9 0 sum_o_9 pulse_h_78 0 5.770293e-8
Gw2_79_9 0 sum_o_9 pulse_h_79 0 -7.254889e-8
Gw2_80_9 0 sum_o_9 pulse_h_80 0 6.455492e-8
Gw2_81_9 0 sum_o_9 pulse_h_81 0 1.345852e-8
Gw2_82_9 0 sum_o_9 pulse_h_82 0 -5.635000e-8
Gw2_83_9 0 sum_o_9 pulse_h_83 0 -1.424312e-7
Gw2_84_9 0 sum_o_9 pulse_h_84 0 -1.916864e-8
Gw2_85_9 0 sum_o_9 pulse_h_85 0 7.688401e-8
Gw2_86_9 0 sum_o_9 pulse_h_86 0 -2.507425e-7
Gw2_87_9 0 sum_o_9 pulse_h_87 0 1.319105e-7
Gw2_88_9 0 sum_o_9 pulse_h_88 0 -1.163349e-7
Gw2_89_9 0 sum_o_9 pulse_h_89 0 -1.079050e-8
Gw2_90_9 0 sum_o_9 pulse_h_90 0 -2.316049e-7
Gw2_91_9 0 sum_o_9 pulse_h_91 0 -3.121207e-8
Gw2_92_9 0 sum_o_9 pulse_h_92 0 6.181231e-8
Gw2_93_9 0 sum_o_9 pulse_h_93 0 3.281379e-8
Gw2_94_9 0 sum_o_9 pulse_h_94 0 -1.014375e-7
Gw2_95_9 0 sum_o_9 pulse_h_95 0 -3.707952e-8
Gw2_96_9 0 sum_o_9 pulse_h_96 0 -5.392087e-9
Gw2_97_9 0 sum_o_9 pulse_h_97 0 1.130885e-7
Gw2_98_9 0 sum_o_9 pulse_h_98 0 6.522438e-8
Gw2_99_9 0 sum_o_9 pulse_h_99 0 -7.964066e-10

* Output layer bias currents
Ib2_0 0 sum_o_0 DC 8.598244e-8
Ib2_1 0 sum_o_1 DC 5.135254e-8
Ib2_2 0 sum_o_2 DC -1.170261e-8
Ib2_3 0 sum_o_3 DC -4.225081e-8
Ib2_4 0 sum_o_4 DC 3.182470e-8
Ib2_5 0 sum_o_5 DC 1.102766e-7
Ib2_6 0 sum_o_6 DC 3.776912e-8
Ib2_7 0 sum_o_7 DC 7.281736e-8
Ib2_8 0 sum_o_8 DC -2.321207e-8
Ib2_9 0 sum_o_9 DC 5.789416e-8

* ========== Simulation ==========
.tran 1.000000e-4 2.500000e-2

.control
run
set filetype=ascii
wrdata gilgamesh_output.txt v(pulse_o_0) v(pulse_o_1) v(pulse_o_2) v(pulse_o_3) v(pulse_o_4) v(pulse_o_5) v(pulse_o_6) v(pulse_o_7) v(pulse_o_8) v(pulse_o_9) v(mem_o_0) v(mem_o_1) v(mem_o_2) v(mem_o_3) v(mem_o_4) v(mem_o_5) v(mem_o_6) v(mem_o_7) v(mem_o_8) v(mem_o_9) v(pulse_h_0) v(mem_h_0) v(pulse_h_1) v(mem_h_1) v(pulse_h_2) v(mem_h_2) v(pulse_h_3) v(mem_h_3) v(pulse_h_4) v(mem_h_4)
quit
.endc

.end
