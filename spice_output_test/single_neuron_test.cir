* Single LIF Neuron Test
* Tests if the circuit can fire with constant input

* LIF Neuron Subcircuit (from gilgamesh)
.subckt lif_neuron mem vref vdd comp_pulse analog_out sum

* Vref buffer
Ebuf vref_buf 0 vref 0 1e5
Rbuf vref_buf vref 1k
Cbuf vref 0 80p
Rvr vref vref_buf 1m

* TIA: Vmem = gain * (Vref - Vsum)
Eint mem 0 vref sum 2e5
Rout_int mem 0 20
Cint mem 0 5p
Cmem mem sum 1e-8
Rleak mem sum 9.5e5

* Threshold divider (places threshold at ~Vref + 0.8V)
Rvh vdd vth_node 3.4e6
Rvl vth_node vref 1.6e6
Rf comp_out vth_node 1e8

* Adaptive threshold
Cadapt vth_node vref 2.2e-8
.model DADAPT D(Is=1e-6 N=1.05 Rs=2 Cjo=1p Eg=0.69)
Rinj comp_out ninj 2.2Meg
Dinj ninj vth_node DADAPT

* Soft comparator: fires when (Vref - mem) > threshold
.param VLO=0
.param VHI=5
.param VSW=0.01
Bdef vdef 0 V = V(vref) - V(mem)
Btheta_rel vtheta_rel 0 V = V(vth_node) - V(vref)
Bcomp comp_raw 0 V = VLO + (VHI - VLO)*(0.5*(1 + tanh( ( V(vdef) - ( V(vtheta_rel) + 0.003 ) ) / VSW )))
Rcout comp_raw comp_out 10
Ccout comp_out 0 4e-9

* Pulse stretching (tau=10ms)
.model DPW D(Is=1e-12 N=1.05 Rs=10 Cjo=1p)
Dpw comp_out comp_pulse DPW
Rpw comp_pulse 0 1e5
Cpw comp_pulse 0 1e-7

* Reset
Rreset mem reset_node 200
Coff_reset reset_node vref 7e-12
Sreset reset_node vref comp_out 0 SWMUX
.model SWMUX SW(Ron=10 Roff=1e9 Vt=2.5 Vh=0.1)

* No analog output
Rana_tie analog_out vref 1Meg

.ends lif_neuron

* Power supplies
Vdd vdd 0 DC 5
Vref vref 0 DC 2.5

* Single neuron
X1 mem vref vdd pulse ana sum lif_neuron

* Constant current injection into summing node
* Positive current should cause membrane to drop below Vref, increasing deflection
Iin 0 sum DC 500n

* Transient analysis: 50ms with 10us steps
.tran 10u 50m

.control
run
set filetype=ascii
wrdata single_neuron_test.txt v(mem) v(pulse)
quit
.endc

.end
